Meridian research operating_point
.param CF=7e-11
.param CR=7e-11
.param SREF=0.02
.param VREF=60
.param LEAK=1000000000000
.param PAR=2e-12
.param CROSS=5e-13
.param LIN=0
.param POLDC=60
.param VS=48
.param FT=0
.param FM=0
.param LEN=10
.param RW=0.1
.param RS=0.05
.param CD=6e-11
.param CS=8e-11
.param ZIN=2000
.param ZM=0
.param CC=2.2e-05
.param CP=2e-10
.param START=0
.param CMAC=0
.param PRESSURE_AC=1
.param PRESSURE_PEAK=0
.param FREQ=1000
.param RHARVESTP_VALUE=2200
.param RHARVESTN_VALUE=2200
.param CRAW_VALUE=4.7e-05
.param RREGTOP_VALUE=100000
.param RREGBOTTOM_VALUE=100000
.param CREGBASE_VALUE=1e-06
.param CRAIL_VALUE=4.7e-05
.param RMIDTOP_VALUE=10000
.param RMIDBOTTOM_VALUE=10000
.param CMID_VALUE=4.7e-05
.param RPOLAR0_VALUE=1000000
.param RPOLAR1_VALUE=1000000
.param RPOLAR2_VALUE=1000000
.param RPOLAR3_VALUE=1000000
.param RPOLAR4_VALUE=1000000
.param RPOLAR5_VALUE=1000000
.param RPOLAR6_VALUE=1000000
.param RPOLAR7_VALUE=1000000
.param RPOLAR8_VALUE=1000000
.param RPOLAR9_VALUE=1000000
.param CPOL_VALUE=1e-07
.param RBACK_VALUE=1000000
.param RSETTOP0_VALUE=10000
.param RSETTOP1_VALUE=10000
.param RSETTOP2_VALUE=10000
.param RSETTOP3_VALUE=10000
.param RSETTOP4_VALUE=10000
.param RSETTOP5_VALUE=10000
.param RSETTOP6_VALUE=10000
.param RSETTOP7_VALUE=10000
.param RSETTOP8_VALUE=10000
.param RSETBOTTOM_VALUE=10000
.param CSET_VALUE=4.7e-05
.param RSENSE_VALUE=1000000
.param CSENSE_VALUE=1e-06
.param RBIAS_VALUE=1000000000
.param CBIASSTRAY_VALUE=2e-13
.param RREAR_VALUE=1000
.param RSOURCE_VALUE=1000
.param CAUDIO_VALUE=1e-06
.param RSIGNAL_VALUE=1000000
.param RINVERTIN_VALUE=10000
.param RINVERTFB_VALUE=10000
.param ROUTP_VALUE=47
.param ROUTN_VALUE=47
.param COUTP_VALUE=4.7e-05
.param COUTN_VALUE=4.7e-05
.temp 25
.options reltol=1e-6 method=gear maxord=2 abstol=1e-15 vntol=1e-9 gmin=1e-15
.include "/home/leobareth/Dokumente/Hardware/audio-works/meridian-microphone/lab/results/runs/20261009T073508Z_e9040470/source/models/capsule/flat_k47.cir"
.include "/home/leobareth/Dokumente/Hardware/audio-works/meridian-microphone/lab/results/runs/20261009T073508Z_e9040470/source/models/environment/p48.cir"
VP pressure 0 DC 0 AC {PRESSURE_AC} SIN(0 {PRESSURE_PEAK} {FREQ})
VPR pressure_r 0 DC 0 AC 0
Xenv p n mic_g pp pn cm P48 VS={VS} FT={FT} FM={FM} LEN={LEN} RW={RW} RS={RS} CD={CD} CS={CS} ZIN={ZIN} ZM={ZM} CC={CC} CP={CP} START={START} CMAC={CMAC}
Xcap f b rear pressure pressure_r mic_g FLAT_K47 CF={CF} CR={CR} SREF={SREF} VREF={VREF} LEAK={LEAK} PAR={PAR} CROSS={CROSS} LIN={LIN} POLDC={POLDC}
* SPDX-License-Identifier: CERN-OHL-S-2.0
* Internal research; no build recommendation.
.subckt DUT f b rear p n g rail
Rharvestp p raw {RHARVESTP_VALUE}
Rharvestn n raw {RHARVESTN_VALUE}
Craw raw g {CRAW_VALUE}
Rregtop raw regbase {RREGTOP_VALUE}
Rregbottom regbase g {RREGBOTTOM_VALUE}
Cregbase regbase g {CREGBASE_VALUE}
VQreg_0 raw Qreg_t0 0
VQreg_1 regbase Qreg_t1 0
VQreg_2 rail Qreg_t2 0
XQreg Qreg_t0 Qreg_t1 Qreg_t2 BC846B
Crail rail g {CRAIL_VALUE}
Rmidtop rail mid {RMIDTOP_VALUE}
Rmidbottom mid g {RMIDBOTTOM_VALUE}
Cmid mid g {CMID_VALUE}
Rpolar0 raw pol_0 {RPOLAR0_VALUE}
Rpolar1 pol_0 pol_1 {RPOLAR1_VALUE}
Rpolar2 pol_1 pol_2 {RPOLAR2_VALUE}
Rpolar3 pol_2 pol_3 {RPOLAR3_VALUE}
Rpolar4 pol_3 pol_4 {RPOLAR4_VALUE}
Rpolar5 pol_4 pol_5 {RPOLAR5_VALUE}
Rpolar6 pol_5 pol_6 {RPOLAR6_VALUE}
Rpolar7 pol_6 pol_7 {RPOLAR7_VALUE}
Rpolar8 pol_7 pol_8 {RPOLAR8_VALUE}
Rpolar9 pol_8 pol {RPOLAR9_VALUE}
Cpol pol g {CPOL_VALUE}
Rback pol b {RBACK_VALUE}
Rsettop0 rail set_div0 {RSETTOP0_VALUE}
Rsettop1 set_div0 set_div1 {RSETTOP1_VALUE}
Rsettop2 set_div1 set_div2 {RSETTOP2_VALUE}
Rsettop3 set_div2 set_div3 {RSETTOP3_VALUE}
Rsettop4 set_div3 set_div4 {RSETTOP4_VALUE}
Rsettop5 set_div4 set_div5 {RSETTOP5_VALUE}
Rsettop6 set_div5 set_div6 {RSETTOP6_VALUE}
Rsettop7 set_div6 set_div7 {RSETTOP7_VALUE}
Rsettop8 set_div7 setpoint {RSETTOP8_VALUE}
Rsetbottom setpoint g {RSETBOTTOM_VALUE}
Cset setpoint g {CSET_VALUE}
Rsense source slow {RSENSE_VALUE}
Csense slow g {CSENSE_VALUE}
VUservo_0 setpoint Uservo_t0 0
VUservo_1 slow Uservo_t1 0
VUservo_2 rail Uservo_t2 0
VUservo_3 g Uservo_t3 0
VUservo_4 servo Uservo_t4 0
XUservo Uservo_t0 Uservo_t1 Uservo_t2 Uservo_t3 Uservo_t4 OPAx197
Rbias f servo {RBIAS_VALUE}
Cbiasstray f servo {CBIASSTRAY_VALUE}
Rrear rear g {RREAR_VALUE}
VJinput_0 rail Jinput_t0 0
VJinput_1 f Jinput_t1 0
VJinput_2 source Jinput_t2 0
VJinput_3 rail Jinput_t3 0
VJinput_4 g Jinput_t4 0
XJinput Jinput_t0 Jinput_t1 Jinput_t2 Jinput_t3 Jinput_t4 JFE150
Rsource source g {RSOURCE_VALUE}
Caudio source signal {CAUDIO_VALUE}
Rsignal signal mid {RSIGNAL_VALUE}
VUoutp_0 signal Uoutp_t0 0
VUoutp_1 outp Uoutp_t1 0
VUoutp_2 rail Uoutp_t2 0
VUoutp_3 g Uoutp_t3 0
VUoutp_4 outp Uoutp_t4 0
XUoutp Uoutp_t0 Uoutp_t1 Uoutp_t2 Uoutp_t3 Uoutp_t4 OPAx197
Rinvertin outp inv {RINVERTIN_VALUE}
Rinvertfb outn inv {RINVERTFB_VALUE}
VUoutn_0 mid Uoutn_t0 0
VUoutn_1 inv Uoutn_t1 0
VUoutn_2 rail Uoutn_t2 0
VUoutn_3 g Uoutn_t3 0
VUoutn_4 outn Uoutn_t4 0
XUoutn Uoutn_t0 Uoutn_t1 Uoutn_t2 Uoutn_t3 Uoutn_t4 OPAx197
Routp outp cp {ROUTP_VALUE}
Routn outn cn {ROUTN_VALUE}
Coutp p cp {COUTP_VALUE}
Coutn n cn {COUTN_VALUE}
.ends DUT

Xdut f b rear p n mic_g rail DUT
.include "/home/leobareth/Dokumente/Hardware/audio-works/meridian-microphone/lab/results/runs/20261009T073508Z_e9040470/source/models/semiconductor/vendor/bc846b_emitter_r1.lib"
.include "/home/leobareth/Dokumente/Hardware/audio-works/meridian-microphone/lab/results/runs/20261009T073508Z_e9040470/source/models/semiconductor/vendor/opa197.lib"
.include "/home/leobareth/Dokumente/Hardware/audio-works/meridian-microphone/lab/results/runs/20261009T073508Z_e9040470/source/models/semiconductor/vendor/jfe150_pspice.lib"

.control
set filetype=ascii
set numdgt=16
op
write op.raw all
quit
.endc
.end
