Meridian research carrier_control
.param CF=7e-11
.param CR=7e-11
.param SREF=0.02
.param VREF=60
.param LEAK=1000000000000
.param PAR=2e-12
.param CROSS=5e-13
.param LIN=0
.param POLDC=60
.param VS=48
.param FT=0
.param FM=0
.param LEN=10
.param RW=0.1
.param RS=0.05
.param CD=6e-11
.param CS=8e-11
.param ZIN=2000
.param ZM=0
.param CC=2.2e-05
.param CP=2e-10
.param START=0
.param CMAC=0
.param PRESSURE_AC=1
.param PRESSURE_PEAK=1
.param FREQ=1000
.param RHARVESTP_VALUE=2200
.param RHARVESTN_VALUE=2200
.param CRAW_VALUE=4.7e-05
.param RREGTOP_VALUE=100000
.param RREGBOTTOM_VALUE=100000
.param CREGBASE_VALUE=1e-06
.param CRAIL_VALUE=4.7e-05
.param RMIDTOP_VALUE=10000
.param RMIDBOTTOM_VALUE=10000
.param CMID_VALUE=4.7e-05
.param RPOLAR0_VALUE=1000000
.param RPOLAR1_VALUE=1000000
.param RPOLAR2_VALUE=1000000
.param RPOLAR3_VALUE=1000000
.param RPOLAR4_VALUE=1000000
.param RPOLAR5_VALUE=1000000
.param RPOLAR6_VALUE=1000000
.param RPOLAR7_VALUE=1000000
.param RPOLAR8_VALUE=1000000
.param RPOLAR9_VALUE=1000000
.param CPOL_VALUE=1e-07
.param RBACK_VALUE=1000000
.param CARRIER_HZ=100000
.param CARRIER_PEAK=0
.param CEXCITE_VALUE=1e-07
.param CBRIDGEF_VALUE=1e-10
.param CBRIDGER_VALUE=1e-10
.param RBIAS_VALUE=1000000000
.param CBIASSTRAY_VALUE=2e-13
.param RREARBIAS_VALUE=1000000000
.param CREARBIASSTRAY_VALUE=2e-13
.param RFILTER1_VALUE=1000
.param CFILTER1_VALUE=1e-07
.param RFILTER2_VALUE=1000
.param CFILTER2_VALUE=1e-07
.param ROUTP_VALUE=47
.param ROUTN_VALUE=47
.param COUTP_VALUE=4.7e-05
.param COUTN_VALUE=4.7e-05
.param RCBRIDGEFLOSS_VALUE=1.5915494309
.param RCBRIDGEFINSULATION_VALUE=10000000000
.param RCBRIDGERLOSS_VALUE=1.5915494309
.param RCBRIDGERINSULATION_VALUE=10000000000
.temp 25
.options reltol=1e-6 method=gear maxord=2 abstol=1e-15 vntol=1e-9 gmin=1e-15
.include "/home/leobareth/Dokumente/Hardware/audio-works/meridian-microphone/lab/results/runs/20261009T090547Z_1f85c513/source/models/capsule/flat_k47.cir"
.include "/home/leobareth/Dokumente/Hardware/audio-works/meridian-microphone/lab/results/runs/20261009T090547Z_1f85c513/source/models/environment/p48.cir"
VP pressure 0 DC 0 AC {PRESSURE_AC} SIN(0 {PRESSURE_PEAK} {FREQ})
VPR pressure_r 0 DC 0 AC 0
Xenv p n mic_g pp pn cm P48 VS={VS} FT={FT} FM={FM} LEN={LEN} RW={RW} RS={RS} CD={CD} CS={CS} ZIN={ZIN} ZM={ZM} CC={CC} CP={CP} START={START} CMAC={CMAC}
Xcap f b rear pressure pressure_r mic_g FLAT_K47 CF={CF} CR={CR} SREF={SREF} VREF={VREF} LEAK={LEAK} PAR={PAR} CROSS={CROSS} LIN={LIN} POLDC={POLDC}
* SPDX-License-Identifier: CERN-OHL-S-2.0
* Internal research; no build recommendation.
.subckt DUT f b rear p n g rail
Rharvestp p raw {RHARVESTP_VALUE}
Rharvestn n raw {RHARVESTN_VALUE}
Craw raw g {CRAW_VALUE}
Rregtop raw regbase {RREGTOP_VALUE}
Rregbottom regbase g {RREGBOTTOM_VALUE}
Cregbase regbase g {CREGBASE_VALUE}
VQreg_0 raw Qreg_t0 0
VQreg_1 regbase Qreg_t1 0
VQreg_2 rail Qreg_t2 0
XQreg Qreg_t0 Qreg_t1 Qreg_t2 BC846B
Crail rail g {CRAIL_VALUE}
Rmidtop rail mid {RMIDTOP_VALUE}
Rmidbottom mid g {RMIDBOTTOM_VALUE}
Cmid mid g {CMID_VALUE}
Rpolar0 raw pol_0 {RPOLAR0_VALUE}
Rpolar1 pol_0 pol_1 {RPOLAR1_VALUE}
Rpolar2 pol_1 pol_2 {RPOLAR2_VALUE}
Rpolar3 pol_2 pol_3 {RPOLAR3_VALUE}
Rpolar4 pol_3 pol_4 {RPOLAR4_VALUE}
Rpolar5 pol_4 pol_5 {RPOLAR5_VALUE}
Rpolar6 pol_5 pol_6 {RPOLAR6_VALUE}
Rpolar7 pol_6 pol_7 {RPOLAR7_VALUE}
Rpolar8 pol_7 pol_8 {RPOLAR8_VALUE}
Rpolar9 pol_8 pol {RPOLAR9_VALUE}
Cpol pol g {CPOL_VALUE}
Rback pol b {RBACK_VALUE}
Bcarrier excite pol V={CARRIER_PEAK*sin(2*PI*CARRIER_HZ*time)}
Banti anti pol V={-CARRIER_PEAK*sin(2*PI*CARRIER_HZ*time)}
Cexcite excite b {CEXCITE_VALUE}
Cbridgef cbridgef_loss anti {CBRIDGEF_VALUE}
Cbridger cbridger_loss anti {CBRIDGER_VALUE}
Rbias f mid {RBIAS_VALUE}
Cbiasstray f mid {CBIASSTRAY_VALUE}
Rrearbias rear mid {RREARBIAS_VALUE}
Crearbiasstray rear mid {CREARBIASSTRAY_VALUE}
Bdemod demod mid V={(v(frontbuf,rearbuf))*2*sin(2*PI*CARRIER_HZ*time)}
Rfilter1 demod lp1 {RFILTER1_VALUE}
Cfilter1 lp1 mid {CFILTER1_VALUE}
Rfilter2 lp1 audio {RFILTER2_VALUE}
Cfilter2 audio mid {CFILTER2_VALUE}
Routp outp cp {ROUTP_VALUE}
Routn outn cn {ROUTN_VALUE}
Coutp p cp {COUTP_VALUE}
Coutn n cn {COUTN_VALUE}
Efront frontbuf g f g 1
Erear rearbuf g rear g 1
Eoutp outp g audio g 1
Eoutn outn g VOL='2*v(mid,g)-v(audio,g)'
RCbridgefloss f cbridgef_loss {RCBRIDGEFLOSS_VALUE}
RCbridgefinsulation f anti {RCBRIDGEFINSULATION_VALUE}
RCbridgerloss rear cbridger_loss {RCBRIDGERLOSS_VALUE}
RCbridgerinsulation rear anti {RCBRIDGERINSULATION_VALUE}
.ends DUT

Xdut f b rear p n mic_g rail DUT
.include "/home/leobareth/Dokumente/Hardware/audio-works/meridian-microphone/lab/results/runs/20261009T090547Z_1f85c513/source/models/semiconductor/vendor/bc846b_emitter_r1.lib"

.control
set filetype=ascii
set numdgt=16
tran 3.125e-07 .03 .02 3.125e-07
write carrier.raw time v(mic_g) v(f) v(b) v(rear) v(pp) v(pn) v(xdut.frontbuf) v(xdut.rearbuf) v(xdut.demod) v(xdut.audio) i(v.xenv.vphantom)
quit
.endc
.end
