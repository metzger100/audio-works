* SPDX-License-Identifier: CERN-OHL-S-2.0
* Internal research; no build recommendation.
.subckt DUT f b rear p n g rail
Rharvestp p raw {RHARVESTP_VALUE}
Rharvestn n raw {RHARVESTN_VALUE}
Craw raw g {CRAW_VALUE}
Rregtop raw regbase {RREGTOP_VALUE}
Rregbottom regbase g {RREGBOTTOM_VALUE}
Cregbase regbase g {CREGBASE_VALUE}
VQreg_0 raw Qreg_t0 0
VQreg_1 regbase Qreg_t1 0
VQreg_2 rail Qreg_t2 0
XQreg Qreg_t0 Qreg_t1 Qreg_t2 BC846B
Crail rail g {CRAIL_VALUE}
Rmidtop rail mid {RMIDTOP_VALUE}
Rmidbottom mid g {RMIDBOTTOM_VALUE}
Cmid mid g {CMID_VALUE}
Rpolar0 raw pol_0 {RPOLAR0_VALUE}
Rpolar1 pol_0 pol_1 {RPOLAR1_VALUE}
Rpolar2 pol_1 pol_2 {RPOLAR2_VALUE}
Rpolar3 pol_2 pol_3 {RPOLAR3_VALUE}
Rpolar4 pol_3 pol_4 {RPOLAR4_VALUE}
Rpolar5 pol_4 pol_5 {RPOLAR5_VALUE}
Rpolar6 pol_5 pol_6 {RPOLAR6_VALUE}
Rpolar7 pol_6 pol_7 {RPOLAR7_VALUE}
Rpolar8 pol_7 pol_8 {RPOLAR8_VALUE}
Rpolar9 pol_8 pol {RPOLAR9_VALUE}
Cpol pol g {CPOL_VALUE}
Rback pol b {RBACK_VALUE}
Rgatetop0 rail gate_div0 {RGATETOP0_VALUE}
Rgatetop1 gate_div0 gate_div1 {RGATETOP1_VALUE}
Rgatetop2 gate_div1 gatebias {RGATETOP2_VALUE}
Rgatebottom gatebias g {RGATEBOTTOM_VALUE}
Cgatebias gatebias g {CGATEBIAS_VALUE}
Rbias f gatebias {RBIAS_VALUE}
Cbiasstray f gatebias {CBIASSTRAY_VALUE}
Rrear rear g {RREAR_VALUE}
VJinput_0 rail Jinput_t0 0
VJinput_1 f Jinput_t1 0
VJinput_2 source Jinput_t2 0
VJinput_3 rail Jinput_t3 0
VJinput_4 g Jinput_t4 0
XJinput Jinput_t0 Jinput_t1 Jinput_t2 Jinput_t3 Jinput_t4 JFE150
Rsource source g {RSOURCE_VALUE}
Caudio source signal {CAUDIO_VALUE}
Rsignal signal mid {RSIGNAL_VALUE}
VUoutp_0 signal Uoutp_t0 0
VUoutp_1 outp Uoutp_t1 0
VUoutp_2 rail Uoutp_t2 0
VUoutp_3 g Uoutp_t3 0
VUoutp_4 outp Uoutp_t4 0
XUoutp Uoutp_t0 Uoutp_t1 Uoutp_t2 Uoutp_t3 Uoutp_t4 OPAx197
Rinvertin outp inv {RINVERTIN_VALUE}
Rinvertfb outn inv {RINVERTFB_VALUE}
VUoutn_0 mid Uoutn_t0 0
VUoutn_1 inv Uoutn_t1 0
VUoutn_2 rail Uoutn_t2 0
VUoutn_3 g Uoutn_t3 0
VUoutn_4 outn Uoutn_t4 0
XUoutn Uoutn_t0 Uoutn_t1 Uoutn_t2 Uoutn_t3 Uoutn_t4 OPAx197
Routp outp cp {ROUTP_VALUE}
Routn outn cn {ROUTN_VALUE}
Coutp p cp {COUTP_VALUE}
Coutn n cn {COUTN_VALUE}
.ends DUT
