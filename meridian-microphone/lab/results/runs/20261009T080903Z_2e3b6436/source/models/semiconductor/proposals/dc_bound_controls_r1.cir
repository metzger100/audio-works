* Project-authored coupled DC bound controls; no noise/capacitance/temperature qualification.
.model DC_BOUND_0 NJF(BETA=0.03151041666666667 VTO=-0.8727272727272728 LAMBDA=0)
.model DC_BOUND_1 NJF(BETA=0.03302857142857143 VTO=-1.029411764705882 LAMBDA=0)
.model DC_BOUND_2 NJF(BETA=0.03478260869565217 VTO=-1.15 LAMBDA=0)
