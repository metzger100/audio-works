Meridian isolated bav199_syntax_r1 reverse_25
* SPDX-License-Identifier: CERN-OHL-S-2.0
.include "/home/leobareth/Dokumente/Hardware/audio-works/meridian-microphone/lab/results/device_models/20261009T133651Z_parts_d3c30763/source/models/semiconductor/vendor/bav199_metadata_r1.lib"
.temp 25
.options reltol=1e-06 abstol=1e-16 vntol=1e-10 gmin=1e-15 method=gear maxord=2
Vr k 0 DC 75 AC 1
Dq 0 k BAV199
.control
set filetype=ascii
set numdgt=16
op
write op.raw i(vr)
quit
.endc
.end
