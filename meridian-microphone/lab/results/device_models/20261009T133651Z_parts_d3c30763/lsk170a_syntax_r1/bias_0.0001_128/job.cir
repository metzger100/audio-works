Meridian isolated lsk170a_syntax_r1 bias_0.0001_128
* SPDX-License-Identifier: CERN-OHL-S-2.0
.include "/home/leobareth/Dokumente/Hardware/audio-works/meridian-microphone/lab/results/device_models/20261009T133651Z_parts_d3c30763/source/models/semiconductor/vendor/lsk170a_metadata_r1.lib"
.temp 25
.options reltol=1e-07 abstol=1e-16 vntol=1e-10 gmin=1e-15 method=gear maxord=2
Vd d 0 10
Vg g 0 DC -0.29858356785862955 AC 1
Jq d g 0 LSK170A
Hout out 0 Vd 1
Hgate ig 0 Vg 1
.control
set filetype=ascii
set numdgt=16
op
write op.raw i(vd) i(vg)
ac dec 128 10 10Meg
write ac.raw i(vd) i(vg)
noise v(out) Vg dec 128 1 100k 1
setplot noise1
write noise.raw all
quit
.endc
.end
