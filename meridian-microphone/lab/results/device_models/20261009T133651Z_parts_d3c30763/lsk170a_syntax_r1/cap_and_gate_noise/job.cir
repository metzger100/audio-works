Meridian isolated lsk170a_syntax_r1 cap_and_gate_noise
* SPDX-License-Identifier: CERN-OHL-S-2.0
.include "/home/leobareth/Dokumente/Hardware/audio-works/meridian-microphone/lab/results/device_models/20261009T133651Z_parts_d3c30763/source/models/semiconductor/vendor/lsk170a_metadata_r1.lib"
.temp 25
.options reltol=1e-06 abstol=1e-16 vntol=1e-10 gmin=1e-15 method=gear maxord=2
Vd d 0 15
Vg g 0 DC -0.3010616059496828 AC 1
Jq d g 0 LSK170A
Hout out 0 Vd 1
Hgate ig 0 Vg 1
.control
set filetype=ascii
set numdgt=16
op
write op.raw i(vg) i(vd)
ac lin 1 1Meg 1Meg
write ac.raw i(vg)
noise v(ig) Vg dec 128 10 100k 1
setplot noise1
write noise.raw all
quit
.endc
.end
