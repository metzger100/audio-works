Meridian isolated jfe2140_vendor transfer_50
* SPDX-License-Identifier: CERN-OHL-S-2.0
.include "/home/leobareth/Dokumente/Hardware/audio-works/meridian-microphone/lab/results/device_models/20261009T133422Z_parts_9ee64bfd/source/models/semiconductor/vendor/jfe2140.lib"
.temp 50
.options reltol=1e-06 abstol=1e-16 vntol=1e-10 gmin=1e-15 method=gear maxord=2
Vd d 0 10
Vg g 0 DC 0 AC 1
Xq d g 0 h l JFEx140
Vh h 0 25
Vl l 0 -5
Hout out 0 Vd 1
Hgate ig 0 Vg 1
.control
set filetype=ascii
set numdgt=16
dc Vg -2 0 .001
write dc.raw v(g) i(vd) i(vg)
quit
.endc
.end
