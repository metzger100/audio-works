Meridian isolated pmbt5551_vendor p48_coupled_isothermal
* SPDX-License-Identifier: CERN-OHL-S-2.0
.include "/home/leobareth/Dokumente/Hardware/audio-works/meridian-microphone/lab/results/device_models/20261009T133422Z_parts_9ee64bfd/source/models/semiconductor/vendor/pmbt5551.lib"
.temp 102
.options reltol=1e-06 abstol=1e-16 vntol=1e-10 gmin=1e-15 method=gear maxord=2
Vc c 0 52
Vin in 0 DC 0.6781388132064673 AC 1
Rsrc in b 1e-06
Xq c b 0 PMBT5551
Hout out 0 Vc 1
.control
set filetype=ascii
set numdgt=16
op
write op.raw i(vc) i(vin)
quit
.endc
.end
