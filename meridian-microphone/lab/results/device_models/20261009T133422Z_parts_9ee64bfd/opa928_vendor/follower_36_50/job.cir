Meridian isolated opa928_vendor follower_36_50
* SPDX-License-Identifier: CERN-OHL-S-2.0
.include "/home/leobareth/Dokumente/Hardware/audio-works/meridian-microphone/lab/results/device_models/20261009T133422Z_parts_9ee64bfd/source/models/semiconductor/vendor/opa928.lib"
.temp 50
.options reltol=1e-06 abstol=1e-16 vntol=1e-10 gmin=1e-15 method=gear maxord=2
Vp p 0 36
Vn n 0 0
Vin in 0 DC 18 AC 1
Xq in out p n out guard1 guard2 OPAX928
Rl out mid 10k
Vm mid 0 18
.options gmin=1e-16
.control
set filetype=ascii
set numdgt=16
op
write op.raw v(out) v(guard1) v(guard2) i(vin) i(vp)
ac dec 64 10 100Meg
write ac.raw v(out)
noise v(out) Vin dec 128 10 100k 1
setplot noise1
write noise.raw all
quit
.endc
.end
