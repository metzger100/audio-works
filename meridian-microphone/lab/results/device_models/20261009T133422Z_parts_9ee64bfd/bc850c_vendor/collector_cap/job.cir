Meridian isolated bc850c_vendor collector_cap
* SPDX-License-Identifier: CERN-OHL-S-2.0
.include "/home/leobareth/Dokumente/Hardware/audio-works/meridian-microphone/lab/results/device_models/20261009T133422Z_parts_9ee64bfd/source/models/semiconductor/vendor/bc850c.lib"
.temp 25
.options reltol=1e-06 abstol=1e-16 vntol=1e-10 gmin=1e-15 method=gear maxord=2
Vc c 0 DC 10 AC 1
Vb b 0 0
Re e 0 1e15
Xq c b e BC850C
.control
set filetype=ascii
set numdgt=16
ac lin 1 1Meg 1Meg
write ac.raw i(vc)
quit
.endc
.end
