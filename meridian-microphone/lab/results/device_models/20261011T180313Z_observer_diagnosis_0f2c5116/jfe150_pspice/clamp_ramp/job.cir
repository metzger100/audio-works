Meridian prerequisite jfe150_pspice clamp_ramp
* SPDX-License-Identifier: CERN-OHL-S-2.0
.temp 25
.options reltol=1e-6 abstol=1e-16 vntol=1e-10 gmin=1e-15 method=gear maxord=2
.include "/home/leobareth/Dokumente/Hardware/audio-works/meridian-microphone/lab/results/device_models/20261011T180313Z_observer_diagnosis_0f2c5116/source/models/semiconductor/vendor/jfe150_pspice.lib"
Vin in 0 PWL(0 -1 .001 -1 .005 1 .009 -1 .010 -1)
Rg in g 100k
Vd d 0 0
Vs s 0 0
Vh h 0 0
Vl l 0 0
Xq d g s h l JFE150
.control
set filetype=ascii
set numdgt=16
tran 1u .010 0 1u
write tran.raw all
quit
.endc
.end
