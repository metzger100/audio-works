Meridian isolated opa197_pspice current_noise
.include "/home/leobareth/Dokumente/Audiotech/meridian/lab/results/device_models/20261005T185102Z_95a6dda5/source/models/semiconductor/vendor/opa197.lib"
.temp 25
.options reltol=1e-06 abstol=1e-16 vntol=1e-10 gmin=1e-15 method=gear maxord=2
Vp p 0 18
Vn n 0 -18
Vin src 0 DC 0 AC 1 SIN(0 20.0 1000)
Vlink src inp 0
Xu inp out p n out OPAx197
Rload out 0 10000

Hinput inoise 0 Vin 1
.control
set filetype=ascii
set numdgt=16
noise v(inoise) Vin dec 64 1 100k 1
setplot noise1
write noise.raw all
quit
.endc
.end
