Meridian isolated bc856b_vendor noise_figure
.include "/home/leobareth/Dokumente/Audiotech/meridian/lab/results/device_models/20261005T185102Z_95a6dda5/source/models/semiconductor/vendor/bc856b.lib"
.temp 25
.options reltol=1e-06 abstol=1e-16 vntol=1e-10 gmin=1e-15 method=gear maxord=2
Vc c 0 -5
Vb inp 0 DC -0.6133308498206878 AC 1
Rsource inp b 2000
Xq c b 0 BC856B
Hout out 0 Vc 1
.control
set filetype=ascii
set numdgt=16
op
write op.raw i(vc) i(vb)
noise v(out) Vb dec 48 1 100k 1
setplot noise1
write noise.raw all
quit
.endc
.end
