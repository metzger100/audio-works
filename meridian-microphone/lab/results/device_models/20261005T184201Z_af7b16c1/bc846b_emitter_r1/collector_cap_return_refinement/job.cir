Meridian isolated bc846b_emitter_r1 collector_cap_return_refinement
.include "/home/leobareth/Dokumente/Audiotech/meridian/lab/results/device_models/20261005T184201Z_af7b16c1/source/models/semiconductor/vendor/bc846b_emitter_r1.lib"
.temp 25
.options reltol=1e-07 abstol=1e-16 vntol=1e-10 gmin=1e-15 method=gear maxord=2
Vc c 0 DC 10 AC 1
Vb b 0 0
Rreturn e b 1G
Xq c b e BC846B
.control
set filetype=ascii
set numdgt=16
ac lin 1 1Meg 1Meg
write ac.raw i(vc)
quit
.endc
.end
