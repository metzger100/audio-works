Meridian isolated jfe150_strong small_noise_0.002
.include "/home/leobareth/Dokumente/Audiotech/meridian/lab/results/device_models/20261005T184201Z_af7b16c1/source/models/semiconductor/vendor/jfe150_strong.lib"
.temp 25
.options reltol=1e-06 abstol=1e-16 vntol=1e-10 gmin=1e-15 method=gear maxord=2
Vd d 0 5
Vg g 0 DC -1.2722865371980814 AC 1
Vh h 0 25
Vl l 0 -5
Xq d g 0 h l JFE150_STRONG
Hout out 0 Vd 1
Hgate ig 0 Vg 1
.control
set filetype=ascii
set numdgt=16
op
write op.raw i(vd) i(vg)
ac dec 48 1 100Meg
write ac.raw i(vd) i(vg)
noise v(out) Vg dec 48 .1 100k 1
setplot noise1
write noise.raw all
noise v(ig) Vg dec 48 .1 100k 1
setplot noise3
write gate_noise.raw all
quit
.endc
.end
