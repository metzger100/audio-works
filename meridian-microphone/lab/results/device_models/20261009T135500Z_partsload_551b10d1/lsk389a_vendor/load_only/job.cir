Meridian isolated lsk389a_vendor load_only
* SPDX-License-Identifier: CERN-OHL-S-2.0
.include "/home/leobareth/Dokumente/Hardware/audio-works/meridian-microphone/lab/results/device_models/20261009T135500Z_partsload_551b10d1/source/models/semiconductor/vendor/lsk389a.lib"
.temp 25
.options reltol=1e-06 abstol=1e-16 vntol=1e-10 gmin=1e-15 method=gear maxord=2
Vd d 0 5
Vg g 0 -.2
Jq d g 0 LSK389A_UPDATED
.control
set filetype=ascii
set numdgt=16
op
write op.raw all
quit
.endc
.end
