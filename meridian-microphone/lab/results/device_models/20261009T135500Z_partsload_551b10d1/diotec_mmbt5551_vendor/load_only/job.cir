Meridian isolated diotec_mmbt5551_vendor load_only
* SPDX-License-Identifier: CERN-OHL-S-2.0
.include "/home/leobareth/Dokumente/Hardware/audio-works/meridian-microphone/lab/results/device_models/20261009T135500Z_partsload_551b10d1/source/models/semiconductor/vendor/diotec_mmbt5551.lib"
.temp 25
.options reltol=1e-06 abstol=1e-16 vntol=1e-10 gmin=1e-15 method=gear maxord=2
Vc c 0 5
Vb b 0 .6
Xq c b 0 MMBT5551
.control
set filetype=ascii
set numdgt=16
op
write op.raw all
quit
.endc
.end
