Meridian isolated lmp7721_vendor load_only
* SPDX-License-Identifier: CERN-OHL-S-2.0
.include "/home/leobareth/Dokumente/Hardware/audio-works/meridian-microphone/lab/results/device_models/20261009T135500Z_partsload_551b10d1/source/models/semiconductor/vendor/lmp7721.lib"
.temp 25
.options reltol=1e-06 abstol=1e-16 vntol=1e-10 gmin=1e-15 method=gear maxord=2
Vp p 0 5
Vn n 0 0
Vin in 0 1
Xq in out p n out LMP7721
Vm mid 0 1
Rl out mid 10k
.options gmin=1e-16
.control
set filetype=ascii
set numdgt=16
op
write op.raw all
quit
.endc
.end
