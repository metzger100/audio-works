Meridian prerequisite jfe150_generic source_0_current_phase_0
* SPDX-License-Identifier: CERN-OHL-S-2.0
.include "/home/leobareth/Dokumente/Hardware/audio-works/meridian-microphone/lab/results/device_models/20261011T180615Z_high_impedance_de3fa943/source/models/semiconductor/vendor/jfe150_generic.lib"
.temp 25
.options reltol=1e-6 abstol=1e-16 vntol=1e-10 gmin=1e-15 method=gear maxord=2
Vrail rail 0 13.5557796144973
Vbias bias 0 DC 3.3889452055659
Vlink bias g 0
Vback back 0 29.5293276326911
Rleak back g 1T
Cgate g back 70p
Rsource s 0 3300
Xq rail g s rail 0 JFE150
Ip 0 g SIN(0 8.29380490383245n 1000 0 0 0)
.control
set filetype=ascii
set numdgt=16
op
write op.raw all
tran 2u .004 0 2u
write tran.raw all
quit
.endc
.end
