Meridian isolated diodes_mmbt5401_vendor coupled_support_44_-10
* SPDX-License-Identifier: CERN-OHL-S-2.0
.include "/home/leobareth/Dokumente/Hardware/audio-works/meridian-microphone/lab/results/device_models/20261009T145346Z_parts2_742caaa3/source/models/semiconductor/vendor/diodes_mmbt5401.lib"
.temp -10
.options reltol=1e-06 abstol=1e-16 vntol=1e-10 gmin=1e-15 method=gear maxord=2
Vc c 0 -44
Vref ref 0 -1.7
Rb ref b 100k
Re e 0 1k
Qq c b e MMBT5401
.control
set filetype=ascii
set numdgt=16
op
write op.raw v(e) v(b) i(vc) i(vref)
quit
.endc
.end
