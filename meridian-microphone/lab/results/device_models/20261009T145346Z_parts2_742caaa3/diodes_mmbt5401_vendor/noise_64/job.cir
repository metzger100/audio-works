Meridian isolated diodes_mmbt5401_vendor noise_64
* SPDX-License-Identifier: CERN-OHL-S-2.0
.include "/home/leobareth/Dokumente/Hardware/audio-works/meridian-microphone/lab/results/device_models/20261009T145346Z_parts2_742caaa3/source/models/semiconductor/vendor/diodes_mmbt5401.lib"
.temp 25
.options reltol=1e-06 abstol=1e-16 vntol=1e-10 gmin=1e-15 method=gear maxord=2
Vc c 0 -5
Vin in 0 DC -0.5714282205835604 AC 1
Rb in b 10
Qq c b 0 MMBT5401
Hout out 0 Vc 1
.control
set filetype=ascii
set numdgt=16
op
write op.raw i(vc)
noise v(out) Vin dec 64 10 100k 1
setplot noise1
write noise.raw all
quit
.endc
.end
