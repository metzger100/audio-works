Meridian isolated opa928_vendor nodeset_translate_20
* SPDX-License-Identifier: CERN-OHL-S-2.0
.include "/home/leobareth/Dokumente/Hardware/audio-works/meridian-microphone/lab/results/device_models/20261009T145346Z_parts2_742caaa3/source/models/semiconductor/vendor/opa928.lib"
.temp 25
.options reltol=1e-06 abstol=1e-16 vntol=1e-10 gmin=1e-15 method=gear maxord=2
Vp p 0 36
Vn n 0 20
Vin in 0 DC 28 AC 1
Xq in out p n out guard1 guard2 OPAX928
Vm mid 0 28
Rl out mid 10k
.nodeset v(out)=28
.options gmin=1e-16
.control
set filetype=ascii
set numdgt=16
op
write op.raw v(out) i(vin) i(vp)
ac dec 64 10 10Meg
write ac.raw v(out)
noise v(out) Vin dec 128 10 100k 1
setplot noise1
write noise.raw all
quit
.endc
.end
