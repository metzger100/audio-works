Meridian isolated lsk389a_syntax_r1 transfer_50
* SPDX-License-Identifier: CERN-OHL-S-2.0
.include "/home/leobareth/Dokumente/Hardware/audio-works/meridian-microphone/lab/results/device_models/20261009T145346Z_parts2_742caaa3/source/models/semiconductor/vendor/lsk389a_metadata_r1.lib"
.temp 50
.options reltol=1e-06 abstol=1e-16 vntol=1e-10 gmin=1e-15 method=gear maxord=2
Vd d 0 10
Vg g 0 DC 0 AC 1
Jq d g 0 LSK389A_UPDATED
Hout out 0 Vd 1
.control
set filetype=ascii
set numdgt=16
dc Vg -2 0 .001
write dc.raw v(g) i(vd)
quit
.endc
.end
