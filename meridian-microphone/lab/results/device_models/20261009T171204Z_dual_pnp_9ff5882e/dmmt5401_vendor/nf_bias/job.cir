Meridian isolated dmmt5401_vendor nf_bias
* SPDX-License-Identifier: CERN-OHL-S-2.0
.include "/home/leobareth/Dokumente/Hardware/audio-works/meridian-microphone/lab/results/device_models/20261009T171204Z_dual_pnp_9ff5882e/source/models/semiconductor/vendor/dmmt5401.lib"
.temp 25
.options reltol=1e-06 abstol=1e-16 vntol=1e-10 gmin=1e-15 method=gear maxord=2
Vc c 0 -5
Vin in 0 DC -0.6 AC 1
Rb in b 10
Xq c b 0 0 0 0 DMMT5401
Hout out 0 Vc 1
.control
set filetype=ascii
set numdgt=16
dc Vin -0.3 -1 -0.0005
write dc.raw v(in) i(vc)
quit
.endc
.end
