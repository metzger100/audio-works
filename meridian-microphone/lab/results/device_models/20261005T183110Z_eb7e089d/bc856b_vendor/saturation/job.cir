Meridian isolated bc856b_vendor saturation
.include "/home/leobareth/Dokumente/Audiotech/meridian/lab/results/device_models/20261005T183110Z_eb7e089d/source/models/semiconductor/vendor/bc856b.lib"
.temp 25
.options reltol=1e-06 abstol=1e-16 vntol=1e-10 gmin=1e-15 method=gear maxord=2
Ic 0 c -0.01
Ib 0 b -0.0005
Xq c b 0 BC856B
.control
set filetype=ascii
set numdgt=16
op
write op.raw v(c) v(b)
quit
.endc
.end
