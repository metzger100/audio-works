Meridian isolated opa197_pspice loaded_supply
.include "/home/leobareth/Dokumente/Audiotech/meridian/lab/results/device_models/20261005T183110Z_eb7e089d/source/models/semiconductor/vendor/opa197.lib"
.temp 25
.options reltol=1e-06 abstol=1e-16 vntol=1e-10 gmin=1e-15 method=gear maxord=2
Vp p 0 18
Vn n 0 -18
Vin src 0 DC 5 AC 1 SIN(0 20 1000)
Vlink src inp 0
Xu inp out p n out OPAx197
Rload out 0 2000
.control
set filetype=ascii
set numdgt=16
op
write op.raw v(out) i(vp) i(vn)
quit
.endc
.end
