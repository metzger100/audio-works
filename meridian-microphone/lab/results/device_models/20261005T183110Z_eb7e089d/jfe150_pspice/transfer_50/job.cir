Meridian isolated jfe150_pspice transfer_50
.include "/home/leobareth/Dokumente/Audiotech/meridian/lab/results/device_models/20261005T183110Z_eb7e089d/source/models/semiconductor/vendor/jfe150_pspice.lib"
.temp 50
.options reltol=1e-06 abstol=1e-16 vntol=1e-10 gmin=1e-15 method=gear maxord=2
Vd d 0 5
Vg g 0 DC -1 AC 1
Vh h 0 5
Vl l 0 -5
Xq d g 0 h l JFE150
Hout out 0 Vd 1
Hgate ig 0 Vg 1
.control
set filetype=ascii
set numdgt=16
dc Vg -1.8 0 .002
write transfer.raw v(g) i(vd) i(vg)
quit
.endc
.end
