Meridian isolated vishay_2n7002k_ps capacitance_gate
* SPDX-License-Identifier: CERN-OHL-S-2.0
.include "/home/leobareth/Dokumente/Hardware/audio-works/meridian-microphone/lab/results/device_models/20261009T070230Z_d5f15884/source/models/semiconductor/vendor/vishay_2n7002k.lib"
.temp 25
.options reltol=1e-06 abstol=1e-16 vntol=1e-10 gmin=1e-15 method=gear maxord=2
Vd d 0 DC 25 AC 0
Vg g 0 DC 0 AC 1
Xq d g 0 2N7002K
Hout out 0 Vd 1
Hgate ig 0 Vg 1
.control
set filetype=ascii
set numdgt=16
ac lin 1 1Meg 1Meg
write ac.raw i(vg) i(vd)
quit
.endc
.end
