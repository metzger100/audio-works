Meridian isolated vishay_2n7002k_ps clipping_1e-06
* SPDX-License-Identifier: CERN-OHL-S-2.0
.include "/home/leobareth/Dokumente/Hardware/audio-works/meridian-microphone/lab/results/device_models/20261009T070419Z_3bd1122a/source/models/semiconductor/vendor/vishay_2n7002k.lib"
.temp 25
.options reltol=1e-07 abstol=1e-16 vntol=1e-10 gmin=1e-15 method=gear maxord=2
Vs rail 0 12
Rd rail d 2k
Vg g 0 SIN(1.7940464505985867 .8 1000)
Xq d g 0 2N7002K
.control
set filetype=ascii
set numdgt=16
tran 1e-06 .02 .01 1e-06
write tran.raw v(d) i(vs)
quit
.endc
.end
