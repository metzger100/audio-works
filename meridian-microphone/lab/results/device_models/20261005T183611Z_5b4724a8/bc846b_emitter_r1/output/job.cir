Meridian isolated bc846b_emitter_r1 output
.include "/home/leobareth/Dokumente/Audiotech/meridian/lab/results/device_models/20261005T183611Z_5b4724a8/source/models/semiconductor/vendor/bc846b_emitter_r1.lib"
.temp 25
.options reltol=1e-06 abstol=1e-16 vntol=1e-10 gmin=1e-15 method=gear maxord=2
Vc c 0 5
Vb inp 0 DC 0.6667733605147436 AC 1
Vlink inp b 0
Xq c b 0 BC846B
Hout out 0 Vc 1
.control
set filetype=ascii
set numdgt=16
dc Vc 0.01 20 0.05
write output.raw v(c) i(vc) i(vb)
quit
.endc
.end
