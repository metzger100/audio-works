Meridian isolated vishay_2n7002k_ps threshold_diode_connected
* SPDX-License-Identifier: CERN-OHL-S-2.0
.include "/home/leobareth/Dokumente/Hardware/audio-works/meridian-microphone/lab/results/device_models/20261009T070130Z_58467dca/source/models/semiconductor/vendor/vishay_2n7002k.lib"
.temp 25
.options reltol=1e-06 abstol=1e-16 vntol=1e-10 gmin=1e-15 method=gear maxord=2
Vg g 0 0
Vlink d g 0
Xq d g 0 2N7002K
.control
set filetype=ascii
set numdgt=16
dc Vg 0 4 .0005
write threshold.raw v(g) i(vlink)
quit
.endc
.end
