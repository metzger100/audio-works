Meridian prerequisite opa928_vendor translation_0_guess_False
* SPDX-License-Identifier: CERN-OHL-S-2.0
.include "/home/leobareth/Dokumente/Hardware/audio-works/meridian-microphone/lab/results/device_models/20261011T175705Z_prerequisites_a7cc0cdb/source/models/semiconductor/vendor/opa928.lib"
.temp 25
.options reltol=1e-6 abstol=1e-16 vntol=1e-10 gmin=1e-15 method=gear maxord=2
Vg g 0 0
Vp p g 16
Vn n g 0
Vin in g DC 8 AC 1 SIN(8 .01 1000)
Vm mid g 8
Rl out mid 10k
Xq in out p n out guard1 guard2 OPAX928
.control
set filetype=ascii
set numdgt=16
op
write op.raw all
ac dec 64 10 10Meg
write ac.raw all
quit
.endc
.end
