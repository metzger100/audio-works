Meridian prerequisite analytic_oracles synthetic
* SPDX-License-Identifier: CERN-OHL-S-2.0
.temp 25
.options reltol=1e-6 abstol=1e-16 vntol=1e-10 gmin=1e-15 method=gear maxord=2
Blin linear 0 V='sin(2*pi*1000*time+.37)'
Bnon out 0 V='v(linear)+.1*v(linear)^2+.04*v(linear)^3+.001/4*sin(4*(2*pi*1000*time+.37)+.13*4)+.001/5*sin(5*(2*pi*1000*time+.37)+.13*5)+.001/6*sin(6*(2*pi*1000*time+.37)+.13*6)+.001/7*sin(7*(2*pi*1000*time+.37)+.13*7)+.001/8*sin(8*(2*pi*1000*time+.37)+.13*8)+.001/9*sin(9*(2*pi*1000*time+.37)+.13*9)+.001/10*sin(10*(2*pi*1000*time+.37)+.13*10)'
.control
set filetype=ascii
set numdgt=16
tran 1u .064 0 1u
write tran.raw all
quit
.endc
.end
