Meridian prerequisite analytic_oracles rc_1e-06
* SPDX-License-Identifier: CERN-OHL-S-2.0
.temp 25
.options reltol=1e-6 abstol=1e-16 vntol=1e-10 gmin=1e-15 method=gear maxord=2
Vin in 0 PWL(0 0 .001 0 .001000001 1 .012 1)
R1 in out 1k
C1 out 0 1u
.control
set filetype=ascii
set numdgt=16
tran 1e-06 .012 0 1e-06
write tran.raw all
quit
.endc
.end
