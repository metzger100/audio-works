Meridian prerequisite bc846b_emitter_r1 open_emitter_cap
* SPDX-License-Identifier: CERN-OHL-S-2.0
.include "/home/leobareth/Dokumente/Hardware/audio-works/meridian-microphone/lab/results/device_models/20261011T175705Z_prerequisites_a7cc0cdb/source/models/semiconductor/vendor/bc846b_emitter_r1.lib"
.temp 25
.options reltol=1e-6 abstol=1e-16 vntol=1e-10 gmin=1e-15 method=gear maxord=2
Vc c 0 DC 10 AC 1
Vb b 0 0
Iopen e 0 0
Xq c b e BC846B
.control
set filetype=ascii
set numdgt=16
ac lin 1 1Meg 1Meg
write ac.raw all
quit
.endc
.end
