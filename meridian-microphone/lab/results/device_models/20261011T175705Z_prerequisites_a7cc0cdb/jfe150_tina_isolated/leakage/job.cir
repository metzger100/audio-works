Meridian prerequisite jfe150_tina_isolated leakage
* SPDX-License-Identifier: CERN-OHL-S-2.0
.include "/home/leobareth/Dokumente/Hardware/audio-works/meridian-microphone/lab/results/device_models/20261011T175705Z_prerequisites_a7cc0cdb/source/research/device_sources/local/20261011T175127Z_prerequisites_40132801/slpm350b/member_001"
.temp 25
.options reltol=1e-6 abstol=1e-16 vntol=1e-10 gmin=1e-15 method=gear maxord=2
Vd d 0 2
Vg g 0 DC -0.7 AC 1
Vs s 0 0
Vh h 0 5
Vl l 0 -5
Xq d g s h l JFE150
Hout out 0 Vd 1
Hgate ig 0 Vg 1
.control
set filetype=ascii
set numdgt=16
op
write op.raw all
quit
.endc
.end
