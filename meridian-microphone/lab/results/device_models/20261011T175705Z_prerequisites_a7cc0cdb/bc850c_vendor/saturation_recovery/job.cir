Meridian prerequisite bc850c_vendor saturation_recovery
* SPDX-License-Identifier: CERN-OHL-S-2.0
.include "/home/leobareth/Dokumente/Hardware/audio-works/meridian-microphone/lab/results/device_models/20261011T175705Z_prerequisites_a7cc0cdb/source/models/semiconductor/vendor/bc850c.lib"
.temp 25
.options reltol=1e-6 abstol=1e-16 vntol=1e-10 gmin=1e-15 method=gear maxord=2
Vrail rail 0 5
Rc rail c 500
Ib 0 b PULSE(0 0.0005 .002 1u 1u .002 .008)
Ve e 0 0
Xq c b e BC850C
.control
set filetype=ascii
set numdgt=16
tran 1u .012 0 1u
write tran.raw all
quit
.endc
.end
