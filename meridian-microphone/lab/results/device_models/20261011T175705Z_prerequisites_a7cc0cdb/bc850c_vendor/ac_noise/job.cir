Meridian prerequisite bc850c_vendor ac_noise
* SPDX-License-Identifier: CERN-OHL-S-2.0
.include "/home/leobareth/Dokumente/Hardware/audio-works/meridian-microphone/lab/results/device_models/20261011T175705Z_prerequisites_a7cc0cdb/source/models/semiconductor/vendor/bc850c.lib"
.temp 25
.options reltol=1e-6 abstol=1e-16 vntol=1e-10 gmin=1e-15 method=gear maxord=2
Vc c 0 5
Vb in 0 DC 0.6642784006264223 AC 1
Rb in b 2000
Ve e 0 0
Xq c b e BC850C
Hout out 0 Vc 1
.control
set filetype=ascii
set numdgt=16
op
write op.raw all
ac dec 64 10 1G
write ac.raw all
noise v(out) Vb dec 128 10 100k 1
setplot noise1
write noise.raw all
quit
.endc
.end
