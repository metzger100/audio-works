Meridian prerequisite jfe150_weak transfer_25
* SPDX-License-Identifier: CERN-OHL-S-2.0
.include "/home/leobareth/Dokumente/Hardware/audio-works/meridian-microphone/lab/results/device_models/20261011T175705Z_prerequisites_a7cc0cdb/source/models/semiconductor/vendor/jfe150_weak.lib"
.temp 25
.options reltol=1e-6 abstol=1e-16 vntol=1e-10 gmin=1e-15 method=gear maxord=2
Vd d 0 5
Vg g 0 DC 0 AC 1
Vs s 0 0
Vh h 0 25
Vl l 0 -5
Xq d g s h l JFE150_WEAK
Hout out 0 Vd 1
Hgate ig 0 Vg 1
.control
set filetype=ascii
set numdgt=16
dc Vg -1.8 0 .001
write dc.raw all
quit
.endc
.end
