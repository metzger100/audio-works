Meridian prerequisite filter_oracle rc_0.0005
* SPDX-License-Identifier: CERN-OHL-S-2.0
.temp 25
.options reltol=1e-6 abstol=1e-16 vntol=1e-10 gmin=1e-15 method=gear maxord=2
Vin in 0 DC 0 AC 1 PWL(0 0 .001 0 .001000001 1 1 1)
R1 in b 1Meg
C1 b 0 100n
.control
set filetype=ascii
set numdgt=16
ac dec 128 20 20k
write ac.raw all
tran 0.0005 1 0 0.0005
write tran.raw all
quit
.endc
.end
