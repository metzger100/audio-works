Meridian prerequisite port_oracle bilateral
* SPDX-License-Identifier: CERN-OHL-S-2.0
.temp 25
.options reltol=1e-6 abstol=1e-16 vntol=1e-10 gmin=1e-15 method=gear maxord=2
Rp p 0 100
Rn n 0 130
Rx p n 2k
Ip 0 p AC 1
In 0 n AC 0
.control
set filetype=ascii
set numdgt=16
ac lin 1 1k 1k
write p.raw all
alter Ip ac=0
alter In ac=1
ac lin 1 1k 1k
write n.raw all
quit
.endc
.end
