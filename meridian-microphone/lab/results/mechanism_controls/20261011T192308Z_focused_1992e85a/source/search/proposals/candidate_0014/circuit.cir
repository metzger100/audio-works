* SPDX-License-Identifier: CERN-OHL-S-2.0
* Internal research; no build recommendation.
.subckt DUT f b rear p n g rail
Rharvestp p raw {RHARVESTP_VALUE}
Rharvestn n raw {RHARVESTN_VALUE}
Craw raw g {CRAW_VALUE}
Rregtop raw regbase {RREGTOP_VALUE}
Rregbottom regbase g {RREGBOTTOM_VALUE}
Cregbase regbase g {CREGBASE_VALUE}
VQreg_0 raw Qreg_t0 0
VQreg_1 regbase Qreg_t1 0
VQreg_2 rail Qreg_t2 0
XQreg Qreg_t0 Qreg_t1 Qreg_t2 BC846B
Crail rail g {CRAIL_VALUE}
Rmidtop rail mid {RMIDTOP_VALUE}
Rmidbottom mid g {RMIDBOTTOM_VALUE}
Cmid mid g {CMID_VALUE}
Rpolar0 raw pol_0 {RPOLAR0_VALUE}
Rpolar1 pol_0 pol_1 {RPOLAR1_VALUE}
Rpolar2 pol_1 pol_2 {RPOLAR2_VALUE}
Rpolar3 pol_2 pol_3 {RPOLAR3_VALUE}
Rpolar4 pol_3 pol_4 {RPOLAR4_VALUE}
Rpolar5 pol_4 pol_5 {RPOLAR5_VALUE}
Rpolar6 pol_5 pol_6 {RPOLAR6_VALUE}
Rpolar7 pol_6 pol_7 {RPOLAR7_VALUE}
Rpolar8 pol_7 pol_8 {RPOLAR8_VALUE}
Rpolar9 pol_8 pol {RPOLAR9_VALUE}
Cpol pol g {CPOL_VALUE}
Rback pol b {RBACK_VALUE}
VUinput_0 mid Uinput_t0 0
VUinput_1 f Uinput_t1 0
VUinput_2 rail Uinput_t2 0
VUinput_3 g Uinput_t3 0
VUinput_4 chargeout Uinput_t4 0
XUinput Uinput_t0 Uinput_t1 Uinput_t2 Uinput_t3 Uinput_t4 OPAx197
Rfeedback chargeout f {RFEEDBACK_VALUE}
Cfeedbackstray chargeout f {CFEEDBACKSTRAY_VALUE}
Cfeedback cfeedback_loss f {CFEEDBACK_VALUE}
Rrear rear g {RREAR_VALUE}
Routp outp cp {ROUTP_VALUE}
Routn outn cn {ROUTN_VALUE}
Coutp p cp {COUTP_VALUE}
Coutn n cn {COUTN_VALUE}
VQoutp_0 rail Qoutp_t0 0
VQoutp_1 chargeout Qoutp_t1 0
VQoutp_2 outp Qoutp_t2 0
XQoutp Qoutp_t0 Qoutp_t1 Qoutp_t2 BC846B
VQinvert_0 inverse Qinvert_t0 0
VQinvert_1 chargeout Qinvert_t1 0
VQinvert_2 ie Qinvert_t2 0
XQinvert Qinvert_t0 Qinvert_t1 Qinvert_t2 BC846B
Rinvemitter ie g {RINVEMITTER_VALUE}
Rinvcollector rail inverse {RINVCOLLECTOR_VALUE}
VQoutn_0 rail Qoutn_t0 0
VQoutn_1 inverse Qoutn_t1 0
VQoutn_2 outn Qoutn_t2 0
XQoutn Qoutn_t0 Qoutn_t1 Qoutn_t2 BC846B
Routloadp outp g {ROUTLOADP_VALUE}
Routloadn outn g {ROUTLOADN_VALUE}
RCfeedbackloss chargeout cfeedback_loss {RCFEEDBACKLOSS_VALUE}
RCfeedbackinsulation chargeout f {RCFEEDBACKINSULATION_VALUE}
.ends DUT
