Meridian research noise
.param CF=4.799727906751308e-11
.param CR=7.000889533166346e-11
.param SREF=0.03534504002544765
.param VREF=60
.param LEAK=60789450864.83527
.param PAR=9.132864969789412e-13
.param CROSS=4.189398143484905e-12
.param LIN=0
.param POLDC=60
.param VS=46.06896423109828
.param FT=-0.1816356818834546
.param FM=0.003923021599948536
.param LEN=93.62154078981517
.param RW=0.08742403052762907
.param RS=0.05
.param CD=9.434031228347903e-11
.param CS=1.886604071598124e-10
.param ZIN=6771.396291904001
.param ZM=0.04096518119154624
.param CC=2.2e-05
.param CP=2e-10
.param START=0
.param CMAC=0
.param PRESSURE_AC=1
.param PRESSURE_PEAK=0
.param FREQ=1000
.param RHARVESTP_VALUE=2219.869010410785
.param RHARVESTN_VALUE=2179.705875596339
.param CRAW_VALUE=4.62439892567443e-05
.param RREGTOP_VALUE=99683.2170549735
.param RREGBOTTOM_VALUE=100518.9444917806
.param CREGBASE_VALUE=1.01249726096131e-06
.param CRAIL_VALUE=4.120337176275006e-05
.param RMIDTOP_VALUE=9973.667112064017
.param RMIDBOTTOM_VALUE=9903.626472778276
.param CMID_VALUE=5.161405633330426e-05
.param RPOLAR0_VALUE=1001044.228615064
.param RPOLAR1_VALUE=1002738.575867088
.param RPOLAR2_VALUE=995055.2944022237
.param RPOLAR3_VALUE=990415.1437005324
.param RPOLAR4_VALUE=999694.3388982
.param RPOLAR5_VALUE=1005150.804332577
.param RPOLAR6_VALUE=1004095.041076258
.param RPOLAR7_VALUE=999979.7776846261
.param RPOLAR8_VALUE=992934.6469464899
.param RPOLAR9_VALUE=997640.8208535553
.param CPOL_VALUE=1.029140351571257e-07
.param RBACK_VALUE=993294.3032250352
.param RBIAS_VALUE=1008458311.421816
.param CBIASSTRAY_VALUE=1.809231182875997e-13
.param RREAR_VALUE=996.3827442374525
.param RSOURCE_VALUE=996.6012046707856
.param CAUDIO_VALUE=1.014337797175034e-06
.param RSIGNAL_VALUE=1001800.07374076
.param ROUTP_VALUE=47.35869772154959
.param ROUTN_VALUE=47.13410625883268
.param RSERVOREF0_VALUE=9911.638209199358
.param RSERVOREF1_VALUE=10006.07874907565
.param RSERVOREF2_VALUE=10026.70035581822
.param RSERVOREF3_VALUE=10018.44291580356
.param RSERVOREF4_VALUE=9977.370976987006
.param RSERVOREF5_VALUE=10082.19942154204
.param RSERVOREF6_VALUE=10076.62055376071
.param RSERVOREF7_VALUE=10039.99490795855
.param RSERVOREF8_VALUE=10037.54356216697
.param RSERVOREF9_VALUE=9916.436817451646
.param RSERVOREF10_VALUE=10022.84626667427
.param RSERVOREF11_VALUE=9922.673789723069
.param RSERVOREF12_VALUE=9933.784628852354
.param RSERVOREF13_VALUE=9915.29669052564
.param RSERVOREF14_VALUE=10071.20250230946
.param RSERVOREFGROUND_VALUE=9972.957292991372
.param CSERVOREF_VALUE=3.962011304845414e-05
.param RSERVOSENSE0_VALUE=99826.23052858164
.param RSERVOSENSE1_VALUE=100318.7804127642
.param RSERVOSENSE2_VALUE=99649.45771822258
.param RSERVOSENSEGROUND_VALUE=99583.55524888827
.param CSERVOSLOW_VALUE=4.627217243745075e-05
.param RSERVOTAIL_VALUE=1005.049070341433
.param RSERVOOUT_VALUE=99702.12830201717
.param RINVEMITTER_VALUE=10010.55117776026
.param RINVCOLLECTOR_VALUE=10001.26414217199
.param ROUTLOADP_VALUE=9924.40050141824
.param ROUTLOADN_VALUE=10027.83491678776
.param COUTP0_VALUE=5.470210714527734e-05
.param RCOUTP0LOSS_VALUE=0.485569841661872
.param RCOUTP0LEAK_VALUE=84889147650.30675
.param COUTP1_VALUE=4.531791570744942e-05
.param RCOUTP1LOSS_VALUE=0.4892748419841915
.param RCOUTP1LEAK_VALUE=15485925380.14118
.param COUTP2_VALUE=4.781568160636909e-05
.param RCOUTP2LOSS_VALUE=1.112705148720454
.param RCOUTP2LEAK_VALUE=2749195.128902972
.param COUTP3_VALUE=5.495614371463814e-05
.param RCOUTP3LOSS_VALUE=1.659180999460933
.param RCOUTP3LEAK_VALUE=9157208707783.289
.param COUTN0_VALUE=5.502597347096148e-05
.param RCOUTN0LOSS_VALUE=0.6446593976371512
.param RCOUTN0LEAK_VALUE=60503965.75709929
.param COUTN1_VALUE=5.437757726528316e-05
.param RCOUTN1LOSS_VALUE=1.459389333503083
.param RCOUTN1LEAK_VALUE=57641885.94511339
.param COUTN2_VALUE=4.417459381478946e-05
.param RCOUTN2LOSS_VALUE=1.725364328332131
.param RCOUTN2LEAK_VALUE=63093045626826.06
.param COUTN3_VALUE=4.423362940812615e-05
.param RCOUTN3LOSS_VALUE=2.13844169227155
.param RCOUTN3LEAK_VALUE=17835927448.01164
.param CBACKFILTER_VALUE=1.059687211123575e-07
.param RCBACKFILTERLOSS_VALUE=0.6736870993540341
.param RCBACKFILTERINSULATION_VALUE=3610451455306.695
.param LBACKFILTER_VALUE=4.331276710009071e-08
.temp 15.151810713013642
.options reltol=1e-6 method=gear maxord=2 abstol=1e-15 vntol=1e-9 gmin=1e-15
.include "/home/leobareth/Dokumente/Hardware/audio-works/meridian-microphone/lab/results/mechanism_controls/20261017T090130Z_comparison002_9392cebd/source/models/capsule/flat-k47.cir"
.include "/home/leobareth/Dokumente/Hardware/audio-works/meridian-microphone/lab/results/mechanism_controls/20261017T090130Z_comparison002_9392cebd/source/models/environment/p48.cir"
VP pressure 0 DC 0 AC {PRESSURE_AC} SIN(0 {PRESSURE_PEAK} {FREQ})
VPR pressure_r 0 DC 0 AC 0
Xenv p n mic_g pp pn cm P48 VS={VS} FT={FT} FM={FM} LEN={LEN} RW={RW} RS={RS} CD={CD} CS={CS} ZIN={ZIN} ZM={ZM} CC={CC} CP={CP} START={START} CMAC={CMAC}
Xcap f b rear pressure pressure_r mic_g FLAT_K47 CF={CF} CR={CR} SREF={SREF} VREF={VREF} LEAK={LEAK} PAR={PAR} CROSS={CROSS} LIN={LIN} POLDC={POLDC}
* SPDX-License-Identifier: CERN-OHL-S-2.0
* Internal research; no build recommendation.
.subckt DUT f b rear p n g rail
Rharvestp p raw {RHARVESTP_VALUE}
Rharvestn n raw {RHARVESTN_VALUE}
Craw raw g {CRAW_VALUE}
Rregtop raw regbase {RREGTOP_VALUE}
Rregbottom regbase g {RREGBOTTOM_VALUE}
Cregbase regbase g {CREGBASE_VALUE}
VQreg_0 raw Qreg_t0 0
VQreg_1 regbase Qreg_t1 0
VQreg_2 rail Qreg_t2 0
XQreg Qreg_t0 Qreg_t1 Qreg_t2 BC846B
Crail rail g {CRAIL_VALUE}
Rmidtop rail mid {RMIDTOP_VALUE}
Rmidbottom mid g {RMIDBOTTOM_VALUE}
Cmid mid g {CMID_VALUE}
Rpolar0 raw pol_0 {RPOLAR0_VALUE}
Rpolar1 pol_0 pol_1 {RPOLAR1_VALUE}
Rpolar2 pol_1 pol_2 {RPOLAR2_VALUE}
Rpolar3 pol_2 pol_3 {RPOLAR3_VALUE}
Rpolar4 pol_3 pol_4 {RPOLAR4_VALUE}
Rpolar5 pol_4 pol_5 {RPOLAR5_VALUE}
Rpolar6 pol_5 pol_6 {RPOLAR6_VALUE}
Rpolar7 pol_6 pol_7 {RPOLAR7_VALUE}
Rpolar8 pol_7 pol_8 {RPOLAR8_VALUE}
Rpolar9 pol_8 pol {RPOLAR9_VALUE}
Cpol pol g {CPOL_VALUE}
Rback pol b {RBACK_VALUE}
Rbias f servo {RBIAS_VALUE}
Cbiasstray f servo {CBIASSTRAY_VALUE}
Rrear rear g {RREAR_VALUE}
VJinput_0 rail Jinput_t0 0
VJinput_1 f Jinput_t1 0
VJinput_2 source Jinput_t2 0
VJinput_3 rail Jinput_t3 0
VJinput_4 g Jinput_t4 0
XJinput Jinput_t0 Jinput_t1 Jinput_t2 Jinput_t3 Jinput_t4 JFE150
Rsource source g {RSOURCE_VALUE}
Caudio source signal {CAUDIO_VALUE}
Rsignal signal mid {RSIGNAL_VALUE}
Routp outp cp {ROUTP_VALUE}
Routn outn cn {ROUTN_VALUE}
Rservoref0 rail set_div0 {RSERVOREF0_VALUE}
Rservoref1 set_div0 set_div1 {RSERVOREF1_VALUE}
Rservoref2 set_div1 set_div2 {RSERVOREF2_VALUE}
Rservoref3 set_div2 set_div3 {RSERVOREF3_VALUE}
Rservoref4 set_div3 set_div4 {RSERVOREF4_VALUE}
Rservoref5 set_div4 set_div5 {RSERVOREF5_VALUE}
Rservoref6 set_div5 set_div6 {RSERVOREF6_VALUE}
Rservoref7 set_div6 set_div7 {RSERVOREF7_VALUE}
Rservoref8 set_div7 set_div8 {RSERVOREF8_VALUE}
Rservoref9 set_div8 set_div9 {RSERVOREF9_VALUE}
Rservoref10 set_div9 set_div10 {RSERVOREF10_VALUE}
Rservoref11 set_div10 set_div11 {RSERVOREF11_VALUE}
Rservoref12 set_div11 set_div12 {RSERVOREF12_VALUE}
Rservoref13 set_div12 set_div13 {RSERVOREF13_VALUE}
Rservoref14 set_div13 setpoint {RSERVOREF14_VALUE}
Rservorefground setpoint g {RSERVOREFGROUND_VALUE}
Cservoref setpoint g {CSERVOREF_VALUE}
Rservosense0 source sense_div0 {RSERVOSENSE0_VALUE}
Rservosense1 sense_div0 sense_div1 {RSERVOSENSE1_VALUE}
Rservosense2 sense_div1 slow {RSERVOSENSE2_VALUE}
Rservosenseground slow g {RSERVOSENSEGROUND_VALUE}
Cservoslow slow g {CSERVOSLOW_VALUE}
VQservoerror_0 servo Qservoerror_t0 0
VQservoerror_1 slow Qservoerror_t1 0
VQservoerror_2 se Qservoerror_t2 0
XQservoerror Qservoerror_t0 Qservoerror_t1 Qservoerror_t2 BC846B
VQservoref_0 rail Qservoref_t0 0
VQservoref_1 setpoint Qservoref_t1 0
VQservoref_2 se Qservoref_t2 0
XQservoref Qservoref_t0 Qservoref_t1 Qservoref_t2 BC846B
Rservotail se g {RSERVOTAIL_VALUE}
Rservoout rail servo {RSERVOOUT_VALUE}
VQoutp_0 rail Qoutp_t0 0
VQoutp_1 signal Qoutp_t1 0
VQoutp_2 outp Qoutp_t2 0
XQoutp Qoutp_t0 Qoutp_t1 Qoutp_t2 BC846B
VQinvert_0 inverse Qinvert_t0 0
VQinvert_1 signal Qinvert_t1 0
VQinvert_2 ie Qinvert_t2 0
XQinvert Qinvert_t0 Qinvert_t1 Qinvert_t2 BC846B
Rinvemitter ie g {RINVEMITTER_VALUE}
Rinvcollector rail inverse {RINVCOLLECTOR_VALUE}
VQoutn_0 rail Qoutn_t0 0
VQoutn_1 inverse Qoutn_t1 0
VQoutn_2 outn Qoutn_t2 0
XQoutn Qoutn_t0 Qoutn_t1 Qoutn_t2 BC846B
Routloadp outp g {ROUTLOADP_VALUE}
Routloadn outn g {ROUTLOADN_VALUE}
Coutp0 coutp0_loss cp {COUTP0_VALUE}
RCoutp0loss p coutp0_loss {RCOUTP0LOSS_VALUE}
RCoutp0leak p cp {RCOUTP0LEAK_VALUE}
Coutp1 coutp1_loss cp {COUTP1_VALUE}
RCoutp1loss p coutp1_loss {RCOUTP1LOSS_VALUE}
RCoutp1leak p cp {RCOUTP1LEAK_VALUE}
Coutp2 coutp2_loss cp {COUTP2_VALUE}
RCoutp2loss p coutp2_loss {RCOUTP2LOSS_VALUE}
RCoutp2leak p cp {RCOUTP2LEAK_VALUE}
Coutp3 coutp3_loss cp {COUTP3_VALUE}
RCoutp3loss p coutp3_loss {RCOUTP3LOSS_VALUE}
RCoutp3leak p cp {RCOUTP3LEAK_VALUE}
Coutn0 coutn0_loss cn {COUTN0_VALUE}
RCoutn0loss n coutn0_loss {RCOUTN0LOSS_VALUE}
RCoutn0leak n cn {RCOUTN0LEAK_VALUE}
Coutn1 coutn1_loss cn {COUTN1_VALUE}
RCoutn1loss n coutn1_loss {RCOUTN1LOSS_VALUE}
RCoutn1leak n cn {RCOUTN1LEAK_VALUE}
Coutn2 coutn2_loss cn {COUTN2_VALUE}
RCoutn2loss n coutn2_loss {RCOUTN2LOSS_VALUE}
RCoutn2leak n cn {RCOUTN2LEAK_VALUE}
Coutn3 coutn3_loss cn {COUTN3_VALUE}
RCoutn3loss n coutn3_loss {RCOUTN3LOSS_VALUE}
RCoutn3leak n cn {RCOUTN3LEAK_VALUE}
Cbackfilter cb_loss g {CBACKFILTER_VALUE}
RCbackfilterloss cb_ind cb_loss {RCBACKFILTERLOSS_VALUE}
Lbackfilter b cb_ind {LBACKFILTER_VALUE}
RCbackfilterinsulation b g {RCBACKFILTERINSULATION_VALUE}
.ends DUT

Xdut f b rear p n mic_g rail DUT
.include "/home/leobareth/Dokumente/Hardware/audio-works/meridian-microphone/lab/results/mechanism_controls/20261017T090130Z_comparison002_9392cebd/source/models/semiconductor/vendor/bc846b_emitter_r1.lib"
.include "/home/leobareth/Dokumente/Hardware/audio-works/meridian-microphone/lab/results/mechanism_controls/20261017T090130Z_comparison002_9392cebd/source/models/semiconductor/vendor/jfe150_pspice.lib"

.control
set filetype=ascii
set numdgt=16
noise v(pp,pn) VP dec 128 20 20k 1
setplot noise1
write noise.raw all
quit
.endc
.end
