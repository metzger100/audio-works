Meridian prerequisite final_network_oracle filtered_adverse
* SPDX-License-Identifier: CERN-OHL-S-2.0
.temp 25
.options reltol=1e-6 abstol=1e-16 vntol=1e-10 gmin=1e-15 method=gear maxord=2
Vraw raw 0 DC 24 AC 1
Rp raw pol 10Meg
Cp pol 0 100n
Rb pol b 1Meg
Iback pol b AC 0
Lfilm b l 5e-08
Rfilm l x 0.7957747154594768
Cfilm x 0 9e-08
Rir b 0 100000000000.0
.control
set filetype=ascii
set numdgt=16
ac dec 128 .001 10Meg
write raw.raw all
alter Vraw ac=0
alter Iback ac=1
ac dec 128 .001 10Meg
write back.raw all
quit
.endc
.end
