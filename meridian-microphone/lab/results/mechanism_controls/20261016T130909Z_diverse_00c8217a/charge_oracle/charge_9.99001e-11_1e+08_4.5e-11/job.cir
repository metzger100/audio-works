Meridian prerequisite charge_oracle charge_9.99001e-11_1e+08_4.5e-11
* SPDX-License-Identifier: CERN-OHL-S-2.0
.temp 25
.options reltol=1e-6 abstol=1e-16 vntol=1e-10 gmin=1e-15 method=gear maxord=2
Icharge 0 f AC 1
Ct f 0 4.7e-11
Rf out f 100000000.0
Cf out f 9.99000999000999e-11
Ee pre 0 f 0 -10
Rp pre pole 1k
Cp pole 0 1.5915494309189535n
Eb out 0 pole 0 1
.control
set filetype=ascii
set numdgt=16
ac dec 64 1 1Meg
write ac.raw all
quit
.endc
.end
