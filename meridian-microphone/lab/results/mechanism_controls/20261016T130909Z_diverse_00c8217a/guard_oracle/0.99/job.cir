Meridian prerequisite guard_oracle 0.99
* SPDX-License-Identifier: CERN-OHL-S-2.0
.temp 25
.options reltol=1e-6 abstol=1e-16 vntol=1e-10 gmin=1e-15 method=gear maxord=2
Itest 0 f AC 1
Rb f 0 1000000000.0
Ct f 0 7.2e-11
Cg f guard 1e-10
Eerr pre 0 f 0 0.99
Rp pre pole 1k
Cp pole 0 1.5915494309189534e-08
Eb guard 0 pole 0 1
.control
set filetype=ascii
set numdgt=16
ac dec 64 1 10Meg
write ac.raw all
quit
.endc
.end
