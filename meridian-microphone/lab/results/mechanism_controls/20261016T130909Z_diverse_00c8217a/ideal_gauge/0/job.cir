Meridian prerequisite ideal_gauge 0
* SPDX-License-Identifier: CERN-OHL-S-2.0
.temp 25
.options reltol=1e-6 abstol=1e-16 vntol=1e-10 gmin=1e-15 method=gear maxord=2
Vg g 0 0
Vin in g DC 8 AC 1
Ebuf out g in g 1
Vm ref g 8
Rl out ref 10k
.control
set filetype=ascii
set numdgt=16
op
write op.raw all
ac lin 1 1k 1k
write ac.raw all
quit
.endc
.end
