Meridian prerequisite reset_oracle reset_9.99001e-11
* SPDX-License-Identifier: CERN-OHL-S-2.0
.temp 25
.options reltol=1e-6 abstol=1e-16 vntol=1e-10 gmin=1e-15 method=gear maxord=2
Istep 0 f PULSE(0 1n 5.3222777222777226e-05 1n 1n 5.3222777222777226e-05 0.0005322277722277723)
Ct f 0 7.2e-11
Rf out f 500000.0
Cf out f 9.99000999000999e-11
Ee out 0 f 0 -10
.control
set filetype=ascii
set numdgt=16
tran 5.322277722277723e-07 0.0004257822177822178 0 5.322277722277723e-07
write tran.raw all
quit
.endc
.end
