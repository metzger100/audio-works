Meridian research bridge_demod_oracle
.param CF=7e-11
.param CR=7e-11
.param SREF=0.02
.param VREF=60
.param LEAK=1000000000000
.param PAR=2e-12
.param CROSS=5e-13
.param LIN=0
.param POLDC=60
.param VS=48
.param FT=0
.param FM=0
.param LEN=10
.param RW=0.1
.param RS=0.05
.param CD=6e-11
.param CS=8e-11
.param ZIN=2000
.param ZM=0
.param CC=2.2e-05
.param CP=2e-10
.param START=0
.param CMAC=0
.param PRESSURE_AC=1
.param PRESSURE_PEAK=0
.param FREQ=1000
.param BIAS_R=1000000000
.param INPUT_C=2e-12
.param GAIN=1
.param OUTPUT_R=75
.param OUTPUT_C=4.7e-05
.param HARVEST_R=100
.param POWER_R=14000
.param STORAGE_C=1e-05
.param POLAR_R=100000000
.temp 25
.options reltol=1e-6 method=gear maxord=2 abstol=1e-15 vntol=1e-9 gmin=1e-15
.include "/home/leobareth/Dokumente/Hardware/audio-works/meridian-microphone/lab/results/mechanism_controls/20261009T081229Z_835f2e55/source/models/capsule/flat_k47.cir"
.include "/home/leobareth/Dokumente/Hardware/audio-works/meridian-microphone/lab/results/mechanism_controls/20261009T081229Z_835f2e55/source/models/environment/p48.cir"
VP pressure 0 DC 0 AC {PRESSURE_AC} SIN(0 {PRESSURE_PEAK} {FREQ})
VPR pressure_r 0 DC 0 AC 0
Xenv p n mic_g pp pn cm P48 VS={VS} FT={FT} FM={FM} LEN={LEN} RW={RW} RS={RS} CD={CD} CS={CS} ZIN={ZIN} ZM={ZM} CC={CC} CP={CP} START={START} CMAC={CMAC}

Vrf bb 0 DC 40 SIN(40 0 100k)
Vanti aa 0 DC 40 SIN(40 0 100k)
Vpressure pf 0 SIN(0 1 1k)
Vrearpressure pr 0 0
Xisland ff bb rr pf pr 0 FLAT_K47 CF=70p CR=70p PAR=1f CROSS=1f LEAK=1e14
Ccomparef ff aa 100p
Ccomparer rr aa 100p
Rreturnf ff 0 1e12
Rreturnr rr 0 1e12
Bproduct dd 0 V=2*(v(ff)-v(rr))*sin(2*pi*100k*time)
Rlp dd recovered 1k
Clp recovered 0 100n
.control
set filetype=ascii
set numdgt=16
tran 3.125e-07 .03 .02 3.125e-07
write control.raw time v(ff) v(rr) v(dd) v(recovered)
quit
.endc
.end
