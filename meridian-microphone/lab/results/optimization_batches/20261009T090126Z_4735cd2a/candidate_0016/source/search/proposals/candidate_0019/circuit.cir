* SPDX-License-Identifier: CERN-OHL-S-2.0
* Internal research; no build recommendation.
.subckt DUT f b rear p n g rail
Rharvestp p raw {RHARVESTP_VALUE}
Rharvestn n raw {RHARVESTN_VALUE}
Craw raw g {CRAW_VALUE}
Rregtop raw regbase {RREGTOP_VALUE}
Rregbottom regbase g {RREGBOTTOM_VALUE}
Cregbase regbase g {CREGBASE_VALUE}
VQreg_0 raw Qreg_t0 0
VQreg_1 regbase Qreg_t1 0
VQreg_2 rail Qreg_t2 0
XQreg Qreg_t0 Qreg_t1 Qreg_t2 BC846B
Crail rail g {CRAIL_VALUE}
Rmidtop rail mid {RMIDTOP_VALUE}
Rmidbottom mid g {RMIDBOTTOM_VALUE}
Cmid mid g {CMID_VALUE}
Rpolar0 raw pol_0 {RPOLAR0_VALUE}
Rpolar1 pol_0 pol_1 {RPOLAR1_VALUE}
Rpolar2 pol_1 pol_2 {RPOLAR2_VALUE}
Rpolar3 pol_2 pol_3 {RPOLAR3_VALUE}
Rpolar4 pol_3 pol_4 {RPOLAR4_VALUE}
Rpolar5 pol_4 pol_5 {RPOLAR5_VALUE}
Rpolar6 pol_5 pol_6 {RPOLAR6_VALUE}
Rpolar7 pol_6 pol_7 {RPOLAR7_VALUE}
Rpolar8 pol_7 pol_8 {RPOLAR8_VALUE}
Rpolar9 pol_8 pol {RPOLAR9_VALUE}
Cpol pol g {CPOL_VALUE}
Rback pol b {RBACK_VALUE}
Rgatetop0 rail gate_div0 {RGATETOP0_VALUE}
Rgatetop1 gate_div0 gate_div1 {RGATETOP1_VALUE}
Rgatetop2 gate_div1 gatebias {RGATETOP2_VALUE}
Rgatebottom gatebias g {RGATEBOTTOM_VALUE}
Cgatebias gatebias g {CGATEBIAS_VALUE}
Rbias f gatebias {RBIAS_VALUE}
Cbiasstray f gatebias {CBIASSTRAY_VALUE}
Rrear rear g {RREAR_VALUE}
VJinput_0 rail Jinput_t0 0
VJinput_1 f Jinput_t1 0
VJinput_2 source Jinput_t2 0
VJinput_3 rail Jinput_t3 0
VJinput_4 g Jinput_t4 0
XJinput Jinput_t0 Jinput_t1 Jinput_t2 Jinput_t3 Jinput_t4 JFE150
Rsource source g {RSOURCE_VALUE}
Caudio source signal {CAUDIO_VALUE}
Rsignal signal mid {RSIGNAL_VALUE}
Routp outp cp {ROUTP_VALUE}
Routn outn cn {ROUTN_VALUE}
VQoutp_0 rail Qoutp_t0 0
VQoutp_1 signal Qoutp_t1 0
VQoutp_2 outp Qoutp_t2 0
XQoutp Qoutp_t0 Qoutp_t1 Qoutp_t2 BC846B
VQinvert_0 inverse Qinvert_t0 0
VQinvert_1 signal Qinvert_t1 0
VQinvert_2 ie Qinvert_t2 0
XQinvert Qinvert_t0 Qinvert_t1 Qinvert_t2 BC846B
Rinvemitter ie g {RINVEMITTER_VALUE}
Rinvcollector rail inverse {RINVCOLLECTOR_VALUE}
VQoutn_0 rail Qoutn_t0 0
VQoutn_1 inverse Qoutn_t1 0
VQoutn_2 outn Qoutn_t2 0
XQoutn Qoutn_t0 Qoutn_t1 Qoutn_t2 BC846B
Routloadp outp g {ROUTLOADP_VALUE}
Routloadn outn g {ROUTLOADN_VALUE}
Cbackfilter b g {CBACKFILTER_VALUE}
Coutp0 coutp0_loss cp {COUTP0_VALUE}
RCoutp0loss p coutp0_loss {RCOUTP0LOSS_VALUE}
RCoutp0leak p cp {RCOUTP0LEAK_VALUE}
Coutp1 coutp1_loss cp {COUTP1_VALUE}
RCoutp1loss p coutp1_loss {RCOUTP1LOSS_VALUE}
RCoutp1leak p cp {RCOUTP1LEAK_VALUE}
Coutp2 coutp2_loss cp {COUTP2_VALUE}
RCoutp2loss p coutp2_loss {RCOUTP2LOSS_VALUE}
RCoutp2leak p cp {RCOUTP2LEAK_VALUE}
Coutp3 coutp3_loss cp {COUTP3_VALUE}
RCoutp3loss p coutp3_loss {RCOUTP3LOSS_VALUE}
RCoutp3leak p cp {RCOUTP3LEAK_VALUE}
Coutn0 coutn0_loss cn {COUTN0_VALUE}
RCoutn0loss n coutn0_loss {RCOUTN0LOSS_VALUE}
RCoutn0leak n cn {RCOUTN0LEAK_VALUE}
Coutn1 coutn1_loss cn {COUTN1_VALUE}
RCoutn1loss n coutn1_loss {RCOUTN1LOSS_VALUE}
RCoutn1leak n cn {RCOUTN1LEAK_VALUE}
Coutn2 coutn2_loss cn {COUTN2_VALUE}
RCoutn2loss n coutn2_loss {RCOUTN2LOSS_VALUE}
RCoutn2leak n cn {RCOUTN2LEAK_VALUE}
Coutn3 coutn3_loss cn {COUTN3_VALUE}
RCoutn3loss n coutn3_loss {RCOUTN3LOSS_VALUE}
RCoutn3leak n cn {RCOUTN3LEAK_VALUE}
.ends DUT
