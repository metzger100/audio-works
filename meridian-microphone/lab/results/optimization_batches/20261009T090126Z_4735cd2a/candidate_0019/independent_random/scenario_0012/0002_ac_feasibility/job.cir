Meridian research ac_feasibility
.param CF=4.68595037317009e-11
.param CR=9.784945682630228e-11
.param SREF=0.02669448670808929
.param VREF=60
.param LEAK=28355185556035.78
.param PAR=5.79102056816379e-12
.param CROSS=9.634200421551653e-13
.param LIN=0
.param POLDC=60
.param VS=44.28572579224368
.param FT=0.0007931668658923419
.param FM=0.003337969057579188
.param LEN=76.11109825131528
.param RW=0.1560522563054318
.param RS=0.05
.param CD=6.18790851851428e-11
.param CS=1.347860179898199e-10
.param ZIN=6046.000367168836
.param ZM=-0.02471755577923458
.param CC=2.2e-05
.param CP=2e-10
.param START=0
.param CMAC=0
.param PRESSURE_AC=1
.param PRESSURE_PEAK=0
.param FREQ=1000
.param RHARVESTP_VALUE=2204.102710909252
.param RHARVESTN_VALUE=2190.472506910697
.param CRAW_VALUE=5.458836133136961e-05
.param RREGTOP_VALUE=100623.5217410527
.param RREGBOTTOM_VALUE=100313.1822231651
.param CREGBASE_VALUE=9.779516206036334e-07
.param CRAIL_VALUE=4.065345241091488e-05
.param RMIDTOP_VALUE=9921.957625994179
.param RMIDBOTTOM_VALUE=9952.174408667195
.param CMID_VALUE=3.999684692655946e-05
.param RPOLAR0_VALUE=990570.4819329485
.param RPOLAR1_VALUE=1009021.867617753
.param RPOLAR2_VALUE=1009859.017702217
.param RPOLAR3_VALUE=999642.0941006617
.param RPOLAR4_VALUE=997199.4120093035
.param RPOLAR5_VALUE=1002770.844974589
.param RPOLAR6_VALUE=1000439.171042939
.param RPOLAR7_VALUE=990646.9323375765
.param RPOLAR8_VALUE=1005839.887911874
.param RPOLAR9_VALUE=1002977.163892567
.param CPOL_VALUE=9.96934044678937e-08
.param RBACK_VALUE=998799.9354798255
.param RGATETOP0_VALUE=9938.344837149885
.param RGATETOP1_VALUE=9956.436327339923
.param RGATETOP2_VALUE=9915.588093268505
.param RGATEBOTTOM_VALUE=10044.22233408196
.param CGATEBIAS_VALUE=5.256940977986628e-05
.param RBIAS_VALUE=1001498003.644694
.param CBIASSTRAY_VALUE=1.023705644179919e-13
.param RREAR_VALUE=992.8474005965627
.param RSOURCE_VALUE=3290.322682423196
.param CAUDIO_VALUE=9.701678296247574e-07
.param RSIGNAL_VALUE=999331.8404585277
.param ROUTP_VALUE=46.84628067343483
.param ROUTN_VALUE=46.87321126724739
.param RINVEMITTER_VALUE=10005.03710177821
.param RINVCOLLECTOR_VALUE=9938.972384070579
.param ROUTLOADP_VALUE=9947.0757918991
.param ROUTLOADN_VALUE=10013.84868834345
.param CBACKFILTER_VALUE=9.642129672960774e-08
.param COUTP0_VALUE=5.582377850364291e-05
.param RCOUTP0LOSS_VALUE=0.7171778728496352
.param RCOUTP0LEAK_VALUE=323433592.7249413
.param COUTP1_VALUE=3.852813988384971e-05
.param RCOUTP1LOSS_VALUE=0.2061069500738604
.param RCOUTP1LEAK_VALUE=19100880929606.03
.param COUTP2_VALUE=5.176642275994721e-05
.param RCOUTP2LOSS_VALUE=2.197214814470748
.param RCOUTP2LEAK_VALUE=531056215797.4023
.param COUTP3_VALUE=3.788999864329323e-05
.param RCOUTP3LOSS_VALUE=2.388709551181594
.param RCOUTP3LEAK_VALUE=407259962739.5729
.param COUTN0_VALUE=4.160325016983525e-05
.param RCOUTN0LOSS_VALUE=2.019379107635678
.param RCOUTN0LEAK_VALUE=3125255332947.411
.param COUTN1_VALUE=5.123404866837815e-05
.param RCOUTN1LOSS_VALUE=0.5119115712682079
.param RCOUTN1LEAK_VALUE=12217385.06153554
.param COUTN2_VALUE=5.57260803421806e-05
.param RCOUTN2LOSS_VALUE=0.2674470956141381
.param RCOUTN2LEAK_VALUE=23008196369.19078
.param COUTN3_VALUE=4.506630452823807e-05
.param RCOUTN3LOSS_VALUE=1.877268019751358
.param RCOUTN3LEAK_VALUE=54004987405.74268
.temp 38.10862321366751
.options reltol=1e-6 method=gear maxord=2 abstol=1e-15 vntol=1e-9 gmin=1e-15
.include "/home/leobareth/Dokumente/Hardware/audio-works/meridian-microphone/lab/results/optimization_batches/20261009T090126Z_4735cd2a/candidate_0019/source/models/capsule/flat_k47.cir"
.include "/home/leobareth/Dokumente/Hardware/audio-works/meridian-microphone/lab/results/optimization_batches/20261009T090126Z_4735cd2a/candidate_0019/source/models/environment/p48.cir"
VP pressure 0 DC 0 AC {PRESSURE_AC} SIN(0 {PRESSURE_PEAK} {FREQ})
VPR pressure_r 0 DC 0 AC 0
Xenv p n mic_g pp pn cm P48 VS={VS} FT={FT} FM={FM} LEN={LEN} RW={RW} RS={RS} CD={CD} CS={CS} ZIN={ZIN} ZM={ZM} CC={CC} CP={CP} START={START} CMAC={CMAC}
Xcap f b rear pressure pressure_r mic_g FLAT_K47 CF={CF} CR={CR} SREF={SREF} VREF={VREF} LEAK={LEAK} PAR={PAR} CROSS={CROSS} LIN={LIN} POLDC={POLDC}
* SPDX-License-Identifier: CERN-OHL-S-2.0
* Internal research; no build recommendation.
.subckt DUT f b rear p n g rail
Rharvestp p raw {RHARVESTP_VALUE}
Rharvestn n raw {RHARVESTN_VALUE}
Craw raw g {CRAW_VALUE}
Rregtop raw regbase {RREGTOP_VALUE}
Rregbottom regbase g {RREGBOTTOM_VALUE}
Cregbase regbase g {CREGBASE_VALUE}
VQreg_0 raw Qreg_t0 0
VQreg_1 regbase Qreg_t1 0
VQreg_2 rail Qreg_t2 0
XQreg Qreg_t0 Qreg_t1 Qreg_t2 BC846B
Crail rail g {CRAIL_VALUE}
Rmidtop rail mid {RMIDTOP_VALUE}
Rmidbottom mid g {RMIDBOTTOM_VALUE}
Cmid mid g {CMID_VALUE}
Rpolar0 raw pol_0 {RPOLAR0_VALUE}
Rpolar1 pol_0 pol_1 {RPOLAR1_VALUE}
Rpolar2 pol_1 pol_2 {RPOLAR2_VALUE}
Rpolar3 pol_2 pol_3 {RPOLAR3_VALUE}
Rpolar4 pol_3 pol_4 {RPOLAR4_VALUE}
Rpolar5 pol_4 pol_5 {RPOLAR5_VALUE}
Rpolar6 pol_5 pol_6 {RPOLAR6_VALUE}
Rpolar7 pol_6 pol_7 {RPOLAR7_VALUE}
Rpolar8 pol_7 pol_8 {RPOLAR8_VALUE}
Rpolar9 pol_8 pol {RPOLAR9_VALUE}
Cpol pol g {CPOL_VALUE}
Rback pol b {RBACK_VALUE}
Rgatetop0 rail gate_div0 {RGATETOP0_VALUE}
Rgatetop1 gate_div0 gate_div1 {RGATETOP1_VALUE}
Rgatetop2 gate_div1 gatebias {RGATETOP2_VALUE}
Rgatebottom gatebias g {RGATEBOTTOM_VALUE}
Cgatebias gatebias g {CGATEBIAS_VALUE}
Rbias f gatebias {RBIAS_VALUE}
Cbiasstray f gatebias {CBIASSTRAY_VALUE}
Rrear rear g {RREAR_VALUE}
VJinput_0 rail Jinput_t0 0
VJinput_1 f Jinput_t1 0
VJinput_2 source Jinput_t2 0
VJinput_3 rail Jinput_t3 0
VJinput_4 g Jinput_t4 0
XJinput Jinput_t0 Jinput_t1 Jinput_t2 Jinput_t3 Jinput_t4 JFE150
Rsource source g {RSOURCE_VALUE}
Caudio source signal {CAUDIO_VALUE}
Rsignal signal mid {RSIGNAL_VALUE}
Routp outp cp {ROUTP_VALUE}
Routn outn cn {ROUTN_VALUE}
VQoutp_0 rail Qoutp_t0 0
VQoutp_1 signal Qoutp_t1 0
VQoutp_2 outp Qoutp_t2 0
XQoutp Qoutp_t0 Qoutp_t1 Qoutp_t2 BC846B
VQinvert_0 inverse Qinvert_t0 0
VQinvert_1 signal Qinvert_t1 0
VQinvert_2 ie Qinvert_t2 0
XQinvert Qinvert_t0 Qinvert_t1 Qinvert_t2 BC846B
Rinvemitter ie g {RINVEMITTER_VALUE}
Rinvcollector rail inverse {RINVCOLLECTOR_VALUE}
VQoutn_0 rail Qoutn_t0 0
VQoutn_1 inverse Qoutn_t1 0
VQoutn_2 outn Qoutn_t2 0
XQoutn Qoutn_t0 Qoutn_t1 Qoutn_t2 BC846B
Routloadp outp g {ROUTLOADP_VALUE}
Routloadn outn g {ROUTLOADN_VALUE}
Cbackfilter b g {CBACKFILTER_VALUE}
Coutp0 coutp0_loss cp {COUTP0_VALUE}
RCoutp0loss p coutp0_loss {RCOUTP0LOSS_VALUE}
RCoutp0leak p cp {RCOUTP0LEAK_VALUE}
Coutp1 coutp1_loss cp {COUTP1_VALUE}
RCoutp1loss p coutp1_loss {RCOUTP1LOSS_VALUE}
RCoutp1leak p cp {RCOUTP1LEAK_VALUE}
Coutp2 coutp2_loss cp {COUTP2_VALUE}
RCoutp2loss p coutp2_loss {RCOUTP2LOSS_VALUE}
RCoutp2leak p cp {RCOUTP2LEAK_VALUE}
Coutp3 coutp3_loss cp {COUTP3_VALUE}
RCoutp3loss p coutp3_loss {RCOUTP3LOSS_VALUE}
RCoutp3leak p cp {RCOUTP3LEAK_VALUE}
Coutn0 coutn0_loss cn {COUTN0_VALUE}
RCoutn0loss n coutn0_loss {RCOUTN0LOSS_VALUE}
RCoutn0leak n cn {RCOUTN0LEAK_VALUE}
Coutn1 coutn1_loss cn {COUTN1_VALUE}
RCoutn1loss n coutn1_loss {RCOUTN1LOSS_VALUE}
RCoutn1leak n cn {RCOUTN1LEAK_VALUE}
Coutn2 coutn2_loss cn {COUTN2_VALUE}
RCoutn2loss n coutn2_loss {RCOUTN2LOSS_VALUE}
RCoutn2leak n cn {RCOUTN2LEAK_VALUE}
Coutn3 coutn3_loss cn {COUTN3_VALUE}
RCoutn3loss n coutn3_loss {RCOUTN3LOSS_VALUE}
RCoutn3leak n cn {RCOUTN3LEAK_VALUE}
.ends DUT

Xdut f b rear p n mic_g rail DUT
.include "/home/leobareth/Dokumente/Hardware/audio-works/meridian-microphone/lab/results/optimization_batches/20261009T090126Z_4735cd2a/candidate_0019/source/models/semiconductor/vendor/bc846b_emitter_r1.lib"
.include "/home/leobareth/Dokumente/Hardware/audio-works/meridian-microphone/lab/results/optimization_batches/20261009T090126Z_4735cd2a/candidate_0019/source/models/semiconductor/vendor/jfe150_pspice.lib"

.control
set filetype=ascii
set numdgt=16
op
write op.raw all
ac dec 32 1 10Meg
write ac.raw all
quit
.endc
.end
