Meridian research ac_transient_oracle
.param CF=7e-11
.param CR=7e-11
.param SREF=0.02
.param VREF=60
.param LEAK=1000000000000
.param PAR=2e-12
.param CROSS=5e-13
.param LIN=1
.param POLDC=40
.param VS=48
.param FT=0
.param FM=0
.param LEN=10
.param RW=0.1
.param RS=0.05
.param CD=6e-11
.param CS=8e-11
.param ZIN=2000
.param ZM=0
.param CC=2.2e-05
.param CP=2e-10
.param START=0
.param CMAC=0
.param PRESSURE_AC=1
.param PRESSURE_PEAK=0.01
.param FREQ=1000
.param BIAS_R=1000000000
.param INPUT_C=2e-12
.param GAIN=1
.param OUTPUT_R=75
.param OUTPUT_C=4.7e-05
.param HARVEST_R=100
.param POWER_R=14000
.param STORAGE_C=1e-05
.param POLAR_R=100000000
.temp 25
.options reltol=1e-6 method=gear maxord=2 abstol=1e-15 vntol=1e-9 gmin=1e-15
.include "/home/leobareth/Dokumente/Hardware/audio-works/meridian-microphone/lab/models/capsule/flat_k47.cir"
.include "/home/leobareth/Dokumente/Hardware/audio-works/meridian-microphone/lab/models/environment/p48.cir"
VP pressure 0 DC 0 AC {PRESSURE_AC} SIN(0 {PRESSURE_PEAK} {FREQ})
VPR pressure_r 0 DC 0 AC 0
Xcap f b rear pressure pressure_r mic_g FLAT_K47 CF={CF} CR={CR} SREF={SREF} VREF={VREF} LEAK={LEAK} PAR={PAR} CROSS={CROSS} LIN={LIN} POLDC={POLDC}
Vg mic_g 0 0
Vbias b mic_g {POLDC}
Rtest f mic_g {BIAS_R}
Ctest f mic_g {INPUT_C}
Rrear rear mic_g 1k

.control
set filetype=ascii
set numdgt=16
ac dec 16 20 20k
write ac.raw all
tran 4u .3 .2 4u
write tran.raw all
quit
.endc
.end
