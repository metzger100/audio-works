* independent passive terminal-admittance control
Vg g 0 DC 0 AC 1
Vd d 0 DC 25 AC 0
Cgs g 0 20p
Cgd g d 3p
Cds d 0 4p
.control
set filetype=ascii
ac lin 1 1Meg 1Meg
write ac.raw i(vg) i(vd)
quit
.endc
.end
