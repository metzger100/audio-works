* independent MOS square-law diode-connected oracle
Vg g 0 1.5
Vlink d g 0
Mcontrol d g 0 0 ORACLE W=1u L=1u
.model ORACLE NMOS(LEVEL=1 VTO=1 KP=.002 LAMBDA=0)
.temp 25
.options tnom=25
.control
set filetype=ascii
op
write op.raw v(g) i(vlink)
quit
.endc
.end
