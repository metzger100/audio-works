* SPDX-License-Identifier: CERN-OHL-S-2.0
* Numerical child: only the internal scaled-Q signal reference changes to global 0.
* Parent flat-k47.cir remains unchanged. No added electrode conductance or bias assist.
* Two electrical diaphragms; pressure scalar voltages relative to global 0 represent Pa.
* Pressure is a non-electrical stimulus, independent of microphone ground/shield potential.
* Scaled Q observer with Gear-2 integration; AC/transient validated by independent oracles.
* No rshunt: see simulator issue 848. Do not suppress floating-node failures.
.subckt FLAT_K47 f b r pf pr g params: CF=70p CR=70p SREF=0.02 VREF=60 LEAK=1e12 PAR=2p CROSS=0.5p LIN=0 POLDC=60
* Numerically scaled charge observer: Vq=Q/1nF; i(Cq)=dQ/dt.
* F copies this current into the physical electrode pair. Same Q law, no B ddt().
Bqf qf 0 V='CF/1n*((1+(1-LIN)*SREF/VREF*v(pf))*v(f,b)-LIN*SREF/VREF*POLDC*v(pf))'
Vqf qf cqf 0
Cqf cqf 0 1n
Ffront f b Vqf 1
Bqr qr 0 V='CR/1n*((1+(1-LIN)*SREF/VREF*v(pr))*v(r,b)-LIN*SREF/VREF*POLDC*v(pr))'
Vqr qr cqr 0
Cqr cqr 0 1n
Frear r b Vqr 1
Rfront f b {LEAK}
Rrear r b {LEAK}
Cparf f g {PAR}
Cparr r g {PAR}
Ccross f r {CROSS}
.ends FLAT_K47
