* SPDX-License-Identifier: CERN-OHL-S-2.0
* Internal research; no build recommendation.
.subckt DUT f b rear p n g rail
Rharvestp p raw {RHARVESTP_VALUE}
Rharvestn n raw {RHARVESTN_VALUE}
Craw raw g {CRAW_VALUE}
Rregtop raw regbase {RREGTOP_VALUE}
Rregbottom regbase g {RREGBOTTOM_VALUE}
Cregbase regbase g {CREGBASE_VALUE}
VQreg_0 raw Qreg_t0 0
VQreg_1 regbase Qreg_t1 0
VQreg_2 rail Qreg_t2 0
XQreg Qreg_t0 Qreg_t1 Qreg_t2 BC846B
Crail rail g {CRAIL_VALUE}
Rmidtop rail mid {RMIDTOP_VALUE}
Rmidbottom mid g {RMIDBOTTOM_VALUE}
Cmid mid g {CMID_VALUE}
Rpolar0 raw pol_0 {RPOLAR0_VALUE}
Rpolar1 pol_0 pol_1 {RPOLAR1_VALUE}
Rpolar2 pol_1 pol_2 {RPOLAR2_VALUE}
Rpolar3 pol_2 pol_3 {RPOLAR3_VALUE}
Rpolar4 pol_3 pol_4 {RPOLAR4_VALUE}
Rpolar5 pol_4 pol_5 {RPOLAR5_VALUE}
Rpolar6 pol_5 pol_6 {RPOLAR6_VALUE}
Rpolar7 pol_6 pol_7 {RPOLAR7_VALUE}
Rpolar8 pol_7 pol_8 {RPOLAR8_VALUE}
Rpolar9 pol_8 pol {RPOLAR9_VALUE}
Cpol pol g {CPOL_VALUE}
Rback pol b {RBACK_VALUE}
Rbias f boot {RBIAS_VALUE}
Cbiasstray f boot {CBIASSTRAY_VALUE}
Rbootdc boot mid {RBOOTDC_VALUE}
VUinput_0 f Uinput_t0 0
VUinput_1 outp Uinput_t1 0
VUinput_2 rail Uinput_t2 0
VUinput_3 g Uinput_t3 0
VUinput_4 outp Uinput_t4 0
XUinput Uinput_t0 Uinput_t1 Uinput_t2 Uinput_t3 Uinput_t4 OPAx197
VUguard_0 outp Uguard_t0 0
VUguard_1 guard Uguard_t1 0
VUguard_2 rail Uguard_t2 0
VUguard_3 g Uguard_t3 0
VUguard_4 guard Uguard_t4 0
XUguard Uguard_t0 Uguard_t1 Uguard_t2 Uguard_t3 Uguard_t4 OPAx197
Cboot guard boot {CBOOT_VALUE}
Cguard f guard {CGUARD_VALUE}
Rguardleak f guard {RGUARDLEAK_VALUE}
Rrear rear g {RREAR_VALUE}
Rinvertin outp inv {RINVERTIN_VALUE}
Rinvertfb outn inv {RINVERTFB_VALUE}
VUoutn_0 mid Uoutn_t0 0
VUoutn_1 inv Uoutn_t1 0
VUoutn_2 rail Uoutn_t2 0
VUoutn_3 g Uoutn_t3 0
VUoutn_4 outn Uoutn_t4 0
XUoutn Uoutn_t0 Uoutn_t1 Uoutn_t2 Uoutn_t3 Uoutn_t4 OPAx197
Routp outp cp {ROUTP_VALUE}
Routn outn cn {ROUTN_VALUE}
Coutp p cp {COUTP_VALUE}
Coutn n cn {COUTN_VALUE}
.ends DUT
