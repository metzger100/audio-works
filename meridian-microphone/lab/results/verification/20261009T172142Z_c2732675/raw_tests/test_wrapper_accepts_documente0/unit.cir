Compatibility control
V1 n 0 1
R1 n 0 1k
.control
op
print i(V1)
quit
.endc
.end
