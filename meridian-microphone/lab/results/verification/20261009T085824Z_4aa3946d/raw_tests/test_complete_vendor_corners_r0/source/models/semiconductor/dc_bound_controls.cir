* Project-authored r2 coupled DC controls; feasible subset only. Original r1 preserved.
* Not production corners; no noise/capacitance/temperature/output/SOA qualification.
.model DC_BOUND_0 NJF(BETA=0.02700892857142857 VTO=-1.018181818181818 LAMBDA=0)
.model DC_BOUND_1 NJF(BETA=0.03302857142857143 VTO=-1.029411764705882 LAMBDA=0)
.model DC_BOUND_2 NJF(BETA=0.03478260869565217 VTO=-1.15 LAMBDA=0)
