* SPDX-License-Identifier: CERN-OHL-S-2.0
* Internal research; no build recommendation.
.subckt DUT f b rear p n g rail
Rharvestp p raw {RHARVESTP_VALUE}
Rharvestn n raw {RHARVESTN_VALUE}
Craw raw g {CRAW_VALUE}
Rregtop raw regbase {RREGTOP_VALUE}
Rregbottom regbase g {RREGBOTTOM_VALUE}
Cregbase regbase g {CREGBASE_VALUE}
VQreg_0 raw Qreg_t0 0
VQreg_1 regbase Qreg_t1 0
VQreg_2 rail Qreg_t2 0
XQreg Qreg_t0 Qreg_t1 Qreg_t2 BC846B
Crail rail g {CRAIL_VALUE}
Rmidtop rail mid {RMIDTOP_VALUE}
Rmidbottom mid g {RMIDBOTTOM_VALUE}
Cmid mid g {CMID_VALUE}
Rpolar0 raw pol_0 {RPOLAR0_VALUE}
Rpolar1 pol_0 pol_1 {RPOLAR1_VALUE}
Rpolar2 pol_1 pol_2 {RPOLAR2_VALUE}
Rpolar3 pol_2 pol_3 {RPOLAR3_VALUE}
Rpolar4 pol_3 pol_4 {RPOLAR4_VALUE}
Rpolar5 pol_4 pol_5 {RPOLAR5_VALUE}
Rpolar6 pol_5 pol_6 {RPOLAR6_VALUE}
Rpolar7 pol_6 pol_7 {RPOLAR7_VALUE}
Rpolar8 pol_7 pol_8 {RPOLAR8_VALUE}
Rpolar9 pol_8 pol {RPOLAR9_VALUE}
Cpol pol g {CPOL_VALUE}
Rback pol b {RBACK_VALUE}
Rreftop rail ref {RREFTOP_VALUE}
Rrefbottom ref g {RREFBOTTOM_VALUE}
Cref ref g {CREF_VALUE}
VQinput_0 outa Qinput_t0 0
VQinput_1 f Qinput_t1 0
VQinput_2 e1 Qinput_t2 0
XQinput Qinput_t0 Qinput_t1 Qinput_t2 BC846B
VQreference_0 outb Qreference_t0 0
VQreference_1 ref Qreference_t1 0
VQreference_2 e2 Qreference_t2 0
XQreference Qreference_t0 Qreference_t1 Qreference_t2 BC846B
Remitter1 e1 tail {REMITTER1_VALUE}
Remitter2 e2 tail {REMITTER2_VALUE}
Rtail tail g {RTAIL_VALUE}
Rcollector1 rail outa {RCOLLECTOR1_VALUE}
Rcollector2 rail outb {RCOLLECTOR2_VALUE}
Cfeedback outa feedback_series {CFEEDBACK_VALUE}
VQoutp_0 rail Qoutp_t0 0
VQoutp_1 outa Qoutp_t1 0
VQoutp_2 outp Qoutp_t2 0
XQoutp Qoutp_t0 Qoutp_t1 Qoutp_t2 BC846B
VQoutn_0 rail Qoutn_t0 0
VQoutn_1 outb Qoutn_t1 0
VQoutn_2 outn Qoutn_t2 0
XQoutn Qoutn_t0 Qoutn_t1 Qoutn_t2 BC846B
Routloadp outp g {ROUTLOADP_VALUE}
Routloadn outn g {ROUTLOADN_VALUE}
Rrear rear g {RREAR_VALUE}
Routp outp cp {ROUTP_VALUE}
Routn outn cn {ROUTN_VALUE}
Coutp p cp {COUTP_VALUE}
Coutn n cn {COUTN_VALUE}
Rfeedbacka outa f {RFEEDBACKA_VALUE}
Rfeedbackb outa f {RFEEDBACKB_VALUE}
Cfeedbackseries cfeedbackseries_loss f {CFEEDBACKSERIES_VALUE}
RCfeedbackseriesloss feedback_series cfeedbackseries_loss {RCFEEDBACKSERIESLOSS_VALUE}
RCfeedbackseriesinsulation feedback_series f {RCFEEDBACKSERIESINSULATION_VALUE}
.ends DUT
