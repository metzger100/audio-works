Meridian isolated bc856b_vendor bandwidth
.include "/home/leobareth/Dokumente/Audiotech/meridian/lab/results/device_models/20261005T184201Z_af7b16c1/source/models/semiconductor/vendor/bc856b.lib"
.temp 25
.options reltol=1e-06 abstol=1e-16 vntol=1e-10 gmin=1e-15 method=gear maxord=2
Vc c 0 -5
Vb inp 0 DC -0.7314272972296709 AC 1
Vlink inp b 0
Xq c b 0 BC856B
Hout out 0 Vc 1
.control
set filetype=ascii
set numdgt=16
op
write op.raw i(vc) i(vb)
ac dec 64 100k 10G
write ac.raw i(vc) i(vb)
quit
.endc
.end
