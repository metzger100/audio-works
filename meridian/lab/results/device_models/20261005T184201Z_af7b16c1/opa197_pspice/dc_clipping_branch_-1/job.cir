Meridian isolated opa197_pspice dc_clipping_branch_-1
.include "/home/leobareth/Dokumente/Audiotech/meridian/lab/results/device_models/20261005T184201Z_af7b16c1/source/models/semiconductor/vendor/opa197.lib"
.temp 25
.options reltol=1e-06 abstol=1e-16 vntol=1e-10 gmin=1e-15 method=gear maxord=2
Vp p 0 18
Vn n 0 -18
Vin src 0 DC 0 AC 1 SIN(0 2.0 1000)
Vlink src inp 0
Xu inp fb p n out OPAx197
Rload out 0 2000
Rf out fb 9k
Rg fb 0 1k
.control
set filetype=ascii
set numdgt=16
dc Vin 0 -2 -0.005
write dc.raw v(out) i(vp) i(vn)
quit
.endc
.end
