Meridian isolated bc856b_vendor transfer_50
.include "/home/leobareth/Dokumente/Audiotech/meridian/lab/results/device_models/20261005T183611Z_5b4724a8/source/models/semiconductor/vendor/bc856b.lib"
.temp 50
.options reltol=1e-06 abstol=1e-16 vntol=1e-10 gmin=1e-15 method=gear maxord=2
Vc c 0 -5
Vb inp 0 DC -0.65 AC 1
Vlink inp b 0
Xq c b 0 BC856B
Hout out 0 Vc 1
.control
set filetype=ascii
set numdgt=16
dc Vb -0.3 -0.9 -0.001
write transfer.raw v(b) i(vc) i(vb)
quit
.endc
.end
