Meridian isolated jfe150_pspice large_signal_1e-06
.include "/home/leobareth/Dokumente/Audiotech/meridian/lab/results/device_models/20261005T183611Z_5b4724a8/source/models/semiconductor/vendor/jfe150_pspice.lib"
.temp 25
.options reltol=1e-07 abstol=1e-16 vntol=1e-10 gmin=1e-15 method=gear maxord=2
Vs rail 0 12
Rd rail d 2k
Vg g 0 DC -0.7264793131891707 SIN(-0.7264793131891707 .5 1000)
Vh h 0 12
Vl l 0 -5
Xq d g 0 h l JFE150
.control
set filetype=ascii
set numdgt=16
tran 1e-06 .02 .01 1e-06
write tran.raw v(d) v(g) i(vs)
quit
.endc
.end
