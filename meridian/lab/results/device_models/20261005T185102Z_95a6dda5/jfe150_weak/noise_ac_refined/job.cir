Meridian isolated jfe150_weak noise_ac_refined
.include "/home/leobareth/Dokumente/Audiotech/meridian/lab/results/device_models/20261005T185102Z_95a6dda5/source/models/semiconductor/vendor/jfe150_weak.lib"
.temp 25
.options reltol=1e-07 abstol=1e-16 vntol=1e-10 gmin=1e-15 method=gear maxord=2
Vd d 0 5
Vg g 0 DC -0.6088803308872266 AC 1
Vh h 0 25
Vl l 0 -5
Xq d g 0 h l JFE150_WEAK
Hout out 0 Vd 1
Hgate ig 0 Vg 1
.control
set filetype=ascii
set numdgt=16
ac dec 96 1 100Meg
write ac.raw i(vd) i(vg)
noise v(out) Vg dec 96 .1 100k 1
setplot noise1
write noise.raw all
quit
.endc
.end
