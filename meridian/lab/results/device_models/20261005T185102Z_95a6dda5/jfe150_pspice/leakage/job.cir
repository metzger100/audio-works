Meridian isolated jfe150_pspice leakage
.include "/home/leobareth/Dokumente/Audiotech/meridian/lab/results/device_models/20261005T185102Z_95a6dda5/source/models/semiconductor/vendor/jfe150_pspice.lib"
.temp 25
.options reltol=1e-06 abstol=1e-16 vntol=1e-10 gmin=1e-15 method=gear maxord=2
Vd d 0 2
Vg g 0 DC -0.7 AC 1
Vh h 0 5
Vl l 0 -5
Xq d g 0 h l JFE150
Hout out 0 Vd 1
Hgate ig 0 Vg 1
.control
set filetype=ascii
set numdgt=16
op
write op.raw i(vg)
quit
.endc
.end
