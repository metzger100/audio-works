Meridian isolated opa197_pspice open_loop_bandwidth
.include "/home/leobareth/Dokumente/Audiotech/meridian/lab/results/device_models/20261005T185102Z_95a6dda5/source/models/semiconductor/vendor/opa197.lib"
.temp 25
.options reltol=1e-06 abstol=1e-16 vntol=1e-10 gmin=1e-15 method=gear maxord=2
Vp p 0 18
Vn n 0 -18
Vin inp 0 DC 0 AC 1
Xu inp inv p n out OPAx197
Lbias out inv 1G
Cbreak inv 0 1
Rload out 0 10k
.control
set filetype=ascii
set numdgt=16
op
write op.raw v(out)
ac dec 96 1 100Meg
write ac.raw v(out) v(inv)
quit
.endc
.end
