Meridian isolated bc846b_emitter_r1 bandwidth
.include "/home/leobareth/Dokumente/Audiotech/meridian/lab/results/device_models/20261005T185102Z_95a6dda5/source/models/semiconductor/vendor/bc846b_emitter_r1.lib"
.temp 25
.options reltol=1e-06 abstol=1e-16 vntol=1e-10 gmin=1e-15 method=gear maxord=2
Vc c 0 5
Vb inp 0 DC 0.7201087947841279 AC 1
Vlink inp b 0
Xq c b 0 BC846B
Hout out 0 Vc 1
.control
set filetype=ascii
set numdgt=16
op
write op.raw i(vc) i(vb)
ac dec 64 100k 10G
write ac.raw i(vc) i(vb)
quit
.endc
.end
